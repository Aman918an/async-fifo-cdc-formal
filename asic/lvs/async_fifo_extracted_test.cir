* cell async_fifo
* pin NWELL,VDD
* pin VSS
* pin empty
* pin full
* pin read_clk
* pin read_data[0]
* pin read_data[1]
* pin read_data[2]
* pin read_data[3]
* pin read_data[4]
* pin read_data[5]
* pin read_data[6]
* pin read_data[7]
* pin read_en
* pin rst_n
* pin write_clk
* pin write_data[0]
* pin write_data[1]
* pin write_data[2]
* pin write_data[3]
* pin write_data[4]
* pin write_data[5]
* pin write_data[6]
* pin write_data[7]
* pin write_en
.SUBCKT async_fifo 13 5 465 301 389 468 467 224 267 276 261 232 231 466 463 266
+ 361 396 1 121 2 61 47 3 329
* net 1 write_data[2]
* net 2 write_data[4]
* net 3 write_data[7]
* net 5 VSS
* net 13 NWELL,VDD
* net 47 write_data[6]
* net 61 write_data[5]
* net 121 write_data[3]
* net 224 read_data[2]
* net 231 read_data[7]
* net 232 read_data[6]
* net 261 read_data[5]
* net 266 write_clk
* net 267 read_data[3]
* net 276 read_data[4]
* net 301 full
* net 329 write_en
* net 361 write_data[0]
* net 389 read_clk
* net 396 write_data[1]
* net 463 rst_n
* net 465 empty
* net 466 read_en
* net 467 read_data[1]
* net 468 read_data[0]
* cell instance $3 r0 *1 8.74,1.4
X$3 1 5 13 8 BUF_X1
* cell instance $8 r0 *1 7.79,1.4
X$8 2 5 13 15 BUF_X1
* cell instance $15 r0 *1 23.56,1.4
X$15 3 5 13 10 BUF_X1
* cell instance $20 r0 *1 20.14,1.4
X$20 15 16 5 13 4 NAND2_X1
* cell instance $22 r0 *1 19.38,1.4
X$22 16 34 4 13 9 5 OAI21_X1
* cell instance $23 m0 *1 9.69,29.4
X$23 348 365 5 13 353 NAND2_X2
* cell instance $24 r0 *1 5.7,29.4
X$24 381 374 5 13 362 NAND2_X2
* cell instance $25 m0 *1 17.67,37.8
X$25 439 429 13 5 470 XNOR2_X1
* cell instance $26 m0 *1 16.53,37.8
X$26 21 438 13 5 439 XNOR2_X1
* cell instance $27 m0 *1 7.79,37.8
X$27 147 432 13 5 421 XNOR2_X1
* cell instance $28 m0 *1 11.97,32.2
X$28 393 296 13 5 422 XNOR2_X1
* cell instance $29 m0 *1 14.63,32.2
X$29 273 385 13 5 366 XNOR2_X1
* cell instance $30 r0 *1 16.15,35
X$30 410 423 13 5 417 XNOR2_X1
* cell instance $31 r0 *1 13.3,29.4
X$31 366 335 13 5 384 XNOR2_X1
* cell instance $32 r0 *1 19.38,26.6
X$32 279 336 297 13 5 77 AND3_X2
* cell instance $33 m0 *1 23.56,40.6
X$33 448 462 5 13 449 NOR2_X2
* cell instance $34 r0 *1 24.13,40.6
X$34 5 472 473 449 259 404 13 DFFS_X1
* cell instance $35 r0 *1 5.7,26.6
X$35 362 307 5 13 306 NOR2_X2
* cell instance $36 r0 *1 6.65,26.6
X$36 330 324 344 5 13 307 NAND3_X2
* cell instance $37 m0 *1 28.12,40.6
X$37 472 464 5 240 13 NAND2_X4
* cell instance $38 r0 *1 10.07,26.6
X$38 311 312 5 277 13 NAND2_X4
* cell instance $39 m0 *1 22.04,35
X$39 5 259 475 412 416 404 13 DFFR_X1
* cell instance $40 m0 *1 10.45,40.6
X$40 5 199 476 469 400 303 13 DFFR_X1
* cell instance $41 m0 *1 5.7,32.2
X$41 5 323 477 352 397 303 13 DFFR_X1
* cell instance $42 m0 *1 9.31,37.8
X$42 5 199 478 425 347 303 13 DFFR_X1
* cell instance $43 m0 *1 14.25,40.6
X$43 5 199 479 432 457 303 13 DFFR_X1
* cell instance $44 m0 *1 5.32,35
X$44 5 323 480 331 414 303 13 DFFR_X1
* cell instance $45 m0 *1 6.65,26.6
X$45 5 323 481 294 306 303 13 DFFR_X1
* cell instance $46 m0 *1 3.99,37.8
X$46 5 323 482 433 432 303 13 DFFR_X1
* cell instance $47 m0 *1 26.98,37.8
X$47 5 259 483 21 428 404 13 DFFR_X1
* cell instance $48 r0 *1 4.18,32.2
X$48 5 323 484 397 407 303 13 DFFR_X1
* cell instance $49 r0 *1 7.98,32.2
X$49 5 323 485 400 364 303 13 DFFR_X1
* cell instance $50 r0 *1 9.5,29.4
X$50 5 323 387 296 355 303 13 DFFR_X1
* cell instance $51 r0 *1 12.16,37.8
X$51 5 199 486 438 425 303 13 DFFR_X1
* cell instance $52 r0 *1 15.96,37.8
X$52 5 199 487 430 419 303 13 DFFR_X1
* cell instance $53 r0 *1 13.49,40.6
X$53 5 199 488 458 469 303 13 DFFR_X1
* cell instance $54 r0 *1 16.53,32.2
X$54 5 199 402 115 409 303 13 DFFR_X1
* cell instance $55 r0 *1 26.22,37.8
X$55 5 259 489 153 440 404 13 DFFR_X1
* cell instance $56 r0 *1 14.44,29.4
X$56 5 238 334 335 333 303 13 DFFR_X1
* cell instance $57 r0 *1 6.08,35
X$57 5 323 490 414 421 303 13 DFFR_X1
* cell instance $58 r0 *1 24.13,32.2
X$58 5 252 491 385 394 404 13 DFFR_X1
* cell instance $59 r0 *1 6.27,37.8
X$59 5 323 492 308 433 303 13 DFFR_X1
* cell instance $60 r0 *1 19.57,35
X$60 5 199 493 416 388 404 13 DFFR_X1
* cell instance $61 r0 *1 20.33,32.2
X$61 5 238 494 394 403 404 13 DFFR_X1
* cell instance $62 r0 *1 12.35,35
X$62 5 199 495 419 422 303 13 DFFR_X1
* cell instance $63 r0 *1 30.59,35
X$63 240 5 13 172 INV_X4
* cell instance $64 r0 *1 29.64,35
X$64 153 5 13 147 INV_X4
* cell instance $65 m0 *1 19.76,35
X$65 402 21 418 13 5 149 HA_X1
* cell instance $66 m0 *1 13.68,35
X$66 21 153 407 13 5 415 HA_X1
* cell instance $67 m0 *1 14.06,26.6
X$67 279 297 496 13 5 315 HA_X1
* cell instance $68 m0 *1 12.35,26.6
X$68 295 296 5 302 13 NAND2_X4
* cell instance $69 m0 *1 21.85,29.4
X$69 115 21 497 13 5 204 HA_X1
* cell instance $70 m0 *1 17.48,26.6
X$70 334 296 498 13 5 299 HA_X1
* cell instance $71 m0 *1 19.38,26.6
X$71 279 299 297 13 5 16 AND3_X2
* cell instance $72 m0 *1 17.1,29.4
X$72 335 387 499 13 5 367 HA_X1
* cell instance $73 m0 *1 16.34,35
X$73 240 402 409 13 5 429 HA_X1
* cell instance $74 m0 *1 16.91,32.2
X$74 335 296 500 13 5 368 HA_X1
* cell instance $75 r0 *1 13.3,26.6
X$75 297 335 347 13 5 295 HA_X1
* cell instance $76 r0 *1 15.2,26.6
X$76 335 315 13 5 332 XNOR2_X1
* cell instance $77 r0 *1 14.63,32.2
X$77 172 115 501 13 5 401 HA_X1
* cell instance $78 r0 *1 17.86,23.8
X$78 279 272 502 13 5 305 HA_X1
* cell instance $79 r0 *1 18.24,29.4
X$79 334 387 388 13 5 336 HA_X1
* cell instance $80 m0 *1 33.44,18.2
X$80 176 219 147 177 5 13 209 NAND4_X1
* cell instance $81 m0 *1 27.74,23.8
X$81 274 281 153 291 5 13 271 NAND4_X1
* cell instance $82 m0 *1 9.88,18.2
X$82 214 203 147 110 5 13 184 NAND4_X1
* cell instance $83 m0 *1 33.25,29.4
X$83 370 325 147 341 5 13 369 NAND4_X1
* cell instance $84 m0 *1 13.49,18.2
X$84 187 217 147 113 5 13 188 NAND4_X1
* cell instance $85 r0 *1 34.96,15.4
X$85 189 160 147 183 5 13 186 NAND4_X1
* cell instance $86 r0 *1 33.25,32.2
X$86 390 408 147 379 5 13 398 NAND4_X1
* cell instance $87 m0 *1 31.73,29.4
X$87 350 357 338 5 13 358 NAND3_X1
* cell instance $88 m0 *1 29.83,23.8
X$88 122 256 257 5 13 291 NAND3_X1
* cell instance $89 m0 *1 38.38,29.4
X$89 122 342 360 5 13 341 NAND3_X1
* cell instance $90 m0 *1 20.9,37.8
X$90 153 204 172 5 13 431 NAND3_X1
* cell instance $91 m0 *1 15.58,15.4
X$91 54 153 168 5 13 144 NAND3_X1
* cell instance $92 m0 *1 37.05,18.2
X$92 122 182 178 5 13 177 NAND3_X1
* cell instance $93 m0 *1 31.92,18.2
X$93 172 220 195 5 13 194 NAND3_X1
* cell instance $94 m0 *1 10.83,18.2
X$94 172 215 184 5 13 205 NAND3_X1
* cell instance $95 m0 *1 30.97,18.2
X$95 158 147 223 5 13 195 NAND3_X1
* cell instance $96 m0 *1 17.67,18.2
X$96 103 153 197 5 13 215 NAND3_X1
* cell instance $97 m0 *1 32.68,18.2
X$97 172 209 193 5 13 190 NAND3_X1
* cell instance $98 m0 *1 12.73,18.2
X$98 172 144 188 5 13 213 NAND3_X1
* cell instance $99 m0 *1 20.71,40.6
X$99 417 443 424 5 13 471 NAND3_X1
* cell instance $100 m0 *1 30.59,15.4
X$100 49 153 142 5 13 161 NAND3_X1
* cell instance $101 m0 *1 32.49,29.4
X$101 358 172 369 5 13 349 NAND3_X1
* cell instance $102 r0 *1 30.78,15.4
X$102 58 153 196 5 13 193 NAND3_X1
* cell instance $103 r0 *1 33.63,15.4
X$103 172 186 161 5 13 185 NAND3_X1
* cell instance $104 r0 *1 26.41,15.4
X$104 71 153 145 5 13 220 NAND3_X1
* cell instance $105 r0 *1 10.64,15.4
X$105 172 167 148 5 13 164 NAND3_X1
* cell instance $106 r0 *1 15.01,15.4
X$106 50 153 192 5 13 167 NAND3_X1
* cell instance $107 r0 *1 32.11,26.6
X$107 122 339 285 5 13 338 NAND3_X1
* cell instance $108 r0 *1 9.31,26.6
X$108 174 331 314 5 13 345 NAND3_X1
* cell instance $109 r0 *1 31.16,32.2
X$109 172 271 398 5 13 454 NAND3_X1
* cell instance $110 r0 *1 25.84,35
X$110 411 412 413 5 13 436 NAND3_X1
* cell instance $111 r0 *1 20.52,37.8
X$111 434 442 431 5 13 443 NAND3_X1
* cell instance $112 r0 *1 24.13,37.8
X$112 436 435 437 5 13 441 NAND3_X1
* cell instance $113 r0 *1 7.98,26.6
X$113 308 345 310 5 13 324 NAND3_X1
* cell instance $114 r0 *1 38.95,29.4
X$114 122 363 382 5 13 379 NAND3_X1
* cell instance $115 r0 *1 11.78,26.6
X$115 311 295 312 5 13 313 NAND3_X1
* cell instance $116 m0 *1 37.05,15.4
X$116 115 127 5 13 178 OR2_X1
* cell instance $117 m0 *1 37.62,29.4
X$117 115 359 5 13 360 OR2_X1
* cell instance $118 m0 *1 40.28,32.2
X$118 115 380 5 13 382 OR2_X1
* cell instance $119 r0 *1 32.87,26.6
X$119 115 319 5 13 339 OR2_X1
* cell instance $120 r0 *1 32.3,23.8
X$120 112 284 5 13 285 OR2_X1
* cell instance $121 r0 *1 7.03,29.4
X$121 353 352 5 13 381 OR2_X1
* cell instance $122 m0 *1 10.64,26.6
X$122 294 5 13 312 INV_X2
* cell instance $123 m0 *1 27.17,32.2
X$123 259 5 13 503 INV_X2
* cell instance $124 m0 *1 9.88,12.6
X$124 28 5 13 504 INV_X2
* cell instance $125 m0 *1 30.59,12.6
X$125 115 5 13 112 INV_X2
* cell instance $126 m0 *1 20.14,23.8
X$126 238 5 13 506 INV_X2
* cell instance $127 m0 *1 35.91,12.6
X$127 25 5 13 507 INV_X2
* cell instance $128 m0 *1 36.48,12.6
X$128 115 85 5 13 116 OR2_X1
* cell instance $129 m0 *1 37.24,12.6
X$129 122 108 116 5 13 183 NAND3_X1
* cell instance $130 m0 *1 10.45,12.6
X$130 91 5 13 28 CLKBUF_X3
* cell instance $131 m0 *1 15.96,32.2
X$131 375 5 13 199 CLKBUF_X3
* cell instance $132 m0 *1 25.65,12.6
X$132 91 5 13 45 CLKBUF_X3
* cell instance $133 m0 *1 10.64,29.4
X$133 91 5 13 323 CLKBUF_X3
* cell instance $134 m0 *1 11.59,29.4
X$134 332 314 174 5 365 13 NAND3_X4
* cell instance $135 m0 *1 34.77,29.4
X$135 91 5 13 239 CLKBUF_X3
* cell instance $136 m0 *1 34.96,12.6
X$136 91 5 13 25 CLKBUF_X3
* cell instance $137 r0 *1 20.14,23.8
X$137 91 5 13 238 CLKBUF_X3
* cell instance $138 r0 *1 23.37,26.6
X$138 91 5 13 252 CLKBUF_X3
* cell instance $139 r0 *1 20.71,29.4
X$139 389 5 13 375 CLKBUF_X3
* cell instance $140 r0 *1 27.93,32.2
X$140 375 5 13 259 CLKBUF_X3
* cell instance $141 r0 *1 22.42,21
X$141 266 5 13 91 CLKBUF_X3
* cell instance $142 m0 *1 32.87,23.8
X$142 258 46 270 5 290 13 AOI21_X1
* cell instance $143 m0 *1 24.7,12.6
X$143 122 98 112 5 133 13 AOI21_X1
* cell instance $144 m0 *1 30.78,21
X$144 236 140 227 5 249 13 AOI21_X1
* cell instance $145 m0 *1 29.64,15.4
X$145 122 112 131 5 157 13 AOI21_X1
* cell instance $146 m0 *1 26.6,12.6
X$146 107 94 114 5 118 13 AOI21_X1
* cell instance $147 m0 *1 19.76,21
X$147 250 94 207 5 265 13 AOI21_X1
* cell instance $148 m0 *1 18.43,15.4
X$148 122 138 112 5 146 13 AOI21_X1
* cell instance $149 m0 *1 28.12,12.6
X$149 143 94 131 5 135 13 AOI21_X1
* cell instance $150 m0 *1 30.4,9.8
X$150 21 18 78 5 84 13 AOI21_X1
* cell instance $151 m0 *1 16.34,7
X$151 21 18 41 5 40 13 AOI21_X1
* cell instance $152 m0 *1 18.62,9.8
X$152 21 18 76 5 82 13 AOI21_X1
* cell instance $153 r0 *1 26.41,12.6
X$153 122 114 112 5 125 13 AOI21_X1
* cell instance $154 r0 *1 22.61,9.8
X$154 83 94 98 5 120 13 AOI21_X1
* cell instance $155 r0 *1 32.11,18.2
X$155 122 227 112 5 235 13 AOI21_X1
* cell instance $156 r0 *1 25.84,4.2
X$156 21 18 22 5 43 13 AOI21_X1
* cell instance $157 r0 *1 29.64,4.2
X$157 21 18 12 5 23 13 AOI21_X1
* cell instance $158 r0 *1 18.24,12.6
X$158 122 105 112 5 137 13 AOI21_X1
* cell instance $159 r0 *1 19.19,18.2
X$159 122 207 112 5 218 13 AOI21_X1
* cell instance $160 r0 *1 19.76,15.4
X$160 154 94 138 5 191 13 AOI21_X1
* cell instance $161 r0 *1 18.43,9.8
X$161 123 94 105 5 104 13 AOI21_X1
* cell instance $162 r0 *1 28.12,29.4
X$162 391 94 356 5 377 13 AOI21_X1
* cell instance $163 r0 *1 29.64,7
X$163 21 18 57 5 64 13 AOI21_X1
* cell instance $164 m0 *1 31.73,23.8
X$164 269 46 5 13 258 NOR2_X1
* cell instance $165 m0 *1 12.54,7
X$165 38 18 5 13 63 NOR2_X1
* cell instance $166 m0 *1 11.97,7
X$166 21 39 5 13 53 NOR2_X1
* cell instance $167 m0 *1 27.36,12.6
X$167 7 94 5 13 107 NOR2_X1
* cell instance $168 m0 *1 30.21,21
X$168 10 140 5 13 236 NOR2_X1
* cell instance $169 m0 *1 27.74,15.4
X$169 59 94 5 13 143 NOR2_X1
* cell instance $170 r0 *1 27.55,29.4
X$170 316 94 5 13 391 NOR2_X1
* cell instance $171 r0 *1 22.8,12.6
X$171 10 94 5 13 83 NOR2_X1
* cell instance $172 r0 *1 11.97,9.8
X$172 73 18 5 13 102 NOR2_X1
* cell instance $173 r0 *1 11.4,9.8
X$173 21 102 5 13 101 NOR2_X1
* cell instance $174 r0 *1 13.68,7
X$174 21 63 5 13 81 NOR2_X1
* cell instance $175 r0 *1 19.95,18.2
X$175 75 94 5 13 250 NOR2_X1
* cell instance $176 r0 *1 19,12.6
X$176 8 94 5 13 123 NOR2_X1
* cell instance $177 r0 *1 20.52,15.4
X$177 15 94 5 13 154 NOR2_X1
* cell instance $178 m0 *1 34.77,21
X$178 248 5 13 227 INV_X1
* cell instance $179 m0 *1 15.96,26.6
X$179 295 5 13 327 INV_X1
* cell instance $180 m0 *1 16.34,26.6
X$180 296 327 5 13 298 NOR2_X2
* cell instance $181 r0 *1 16.53,26.6
X$181 298 279 5 13 174 NAND2_X2
* cell instance $182 m0 *1 14.63,29.4
X$182 332 5 13 333 INV_X1
* cell instance $183 m0 *1 22.04,37.8
X$183 204 5 13 456 INV_X1
* cell instance $184 m0 *1 25.46,37.8
X$184 412 5 13 426 INV_X1
* cell instance $185 m0 *1 41.23,26.6
X$185 286 5 13 321 INV_X1
* cell instance $186 m0 *1 25.65,4.2
X$186 33 5 13 22 INV_X1
* cell instance $187 m0 *1 18.81,40.6
X$187 455 5 13 446 INV_X1
* cell instance $188 m0 *1 19.38,15.4
X$188 139 5 13 138 INV_X1
* cell instance $189 m0 *1 15.77,37.8
X$189 432 5 13 423 INV_X1
* cell instance $190 m0 *1 20.52,12.6
X$190 119 5 13 105 INV_X1
* cell instance $191 m0 *1 33.63,37.8
X$191 453 5 13 420 INV_X1
* cell instance $192 m0 *1 30.59,7
X$192 65 5 13 57 INV_X1
* cell instance $193 m0 *1 36.86,23.8
X$193 289 5 13 270 INV_X1
* cell instance $194 m0 *1 34.39,29.4
X$194 239 5 13 508 INV_X1
* cell instance $195 m0 *1 21.47,7
X$195 42 5 13 41 INV_X1
* cell instance $196 m0 *1 21.66,35
X$196 418 5 13 403 INV_X1
* cell instance $197 m0 *1 30.59,4.2
X$197 26 5 13 12 INV_X1
* cell instance $198 m0 *1 20.52,9.8
X$198 96 5 13 76 INV_X1
* cell instance $199 m0 *1 20.52,21
X$199 251 5 13 207 INV_X1
* cell instance $200 m0 *1 22.61,40.6
X$200 444 5 13 462 INV_X1
* cell instance $201 m0 *1 26.79,26.6
X$201 252 5 13 509 INV_X1
* cell instance $202 m0 *1 32.11,9.8
X$202 93 5 13 78 INV_X1
* cell instance $203 m0 *1 41.8,18.2
X$203 180 5 13 210 INV_X1
* cell instance $204 m0 *1 31.35,29.4
X$204 371 5 13 357 INV_X1
* cell instance $205 m0 *1 30.97,32.2
X$205 399 5 13 356 INV_X1
* cell instance $206 r0 *1 6.65,29.4
X$206 383 5 13 374 INV_X1
* cell instance $207 r0 *1 24.32,9.8
X$207 106 5 13 98 INV_X1
* cell instance $208 r0 *1 30.02,29.4
X$208 149 5 13 392 INV_X1
* cell instance $209 r0 *1 11.78,32.2
X$209 400 5 13 393 INV_X1
* cell instance $210 r0 *1 9.12,29.4
X$210 323 5 13 510 INV_X1
* cell instance $211 r0 *1 7.98,29.4
X$211 331 5 13 354 INV_X1
* cell instance $212 r0 *1 30.78,12.6
X$212 130 5 13 131 INV_X1
* cell instance $213 r0 *1 17.29,40.6
X$213 417 5 13 457 INV_X1
* cell instance $214 r0 *1 30.78,23.8
X$214 292 5 13 283 INV_X1
* cell instance $215 r0 *1 23.75,37.8
X$215 435 5 13 440 INV_X1
* cell instance $216 r0 *1 18.43,40.6
X$216 458 5 13 459 INV_X1
* cell instance $217 r0 *1 27.17,12.6
X$217 134 5 13 114 INV_X1
* cell instance $218 r0 *1 19,26.6
X$218 21 5 13 122 INV_X1
* cell instance $219 r0 *1 40.28,26.6
X$219 322 5 13 320 INV_X1
* cell instance $220 r0 *1 39.9,9.8
X$220 88 5 13 86 INV_X1
* cell instance $221 r0 *1 20.14,37.8
X$221 430 5 13 434 INV_X1
* cell instance $222 r0 *1 31.54,40.6
X$222 474 5 13 451 INV_X1
* cell instance $223 m0 *1 24.32,7
X$223 10 46 55 5 13 67 MUX2_X1
* cell instance $224 m0 *1 31.92,15.4
X$224 7 140 159 5 13 162 MUX2_X1
* cell instance $225 m0 *1 24.7,21
X$225 10 174 226 5 13 254 MUX2_X1
* cell instance $226 m0 *1 23.75,29.4
X$226 337 173 316 5 13 373 MUX2_X1
* cell instance $227 m0 *1 25.46,18.2
X$227 7 174 175 5 13 222 MUX2_X1
* cell instance $228 m0 *1 15.77,9.8
X$228 75 46 69 5 13 68 MUX2_X1
* cell instance $229 m0 *1 17.1,9.8
X$229 91 5 13 6 CLKBUF_X3
* cell instance $230 m0 *1 18.05,9.8
X$230 6 5 13 505 INV_X2
* cell instance $231 m0 *1 32.11,32.2
X$231 316 140 378 5 13 386 MUX2_X1
* cell instance $232 m0 *1 23.75,23.8
X$232 293 173 269 5 13 275 MUX2_X1
* cell instance $233 m0 *1 24.89,9.8
X$233 10 36 99 5 13 100 MUX2_X1
* cell instance $234 m0 *1 29.07,26.6
X$234 284 16 316 5 13 326 MUX2_X1
* cell instance $235 m0 *1 38.38,32.2
X$235 269 36 380 5 13 395 MUX2_X1
* cell instance $236 m0 *1 10.26,15.4
X$236 8 140 165 5 13 128 MUX2_X1
* cell instance $237 m0 *1 10.83,9.8
X$237 75 36 73 5 13 72 MUX2_X1
* cell instance $238 m0 *1 7.79,15.4
X$238 75 140 136 5 13 141 MUX2_X1
* cell instance $239 m0 *1 9.69,7
X$239 8 36 38 5 13 37 MUX2_X1
* cell instance $240 m0 *1 8.55,12.6
X$240 111 77 15 5 13 117 MUX2_X1
* cell instance $241 m0 *1 33.82,26.6
X$241 316 46 319 5 13 318 MUX2_X1
* cell instance $242 m0 *1 36.29,29.4
X$242 316 36 359 5 13 340 MUX2_X1
* cell instance $243 m0 *1 13.11,9.8
X$243 80 77 8 5 13 90 MUX2_X1
* cell instance $244 m0 *1 9.12,9.8
X$244 79 77 75 5 13 89 MUX2_X1
* cell instance $245 r0 *1 8.74,21
X$245 75 174 255 5 13 264 MUX2_X1
* cell instance $246 r0 *1 24.32,26.6
X$246 316 174 317 5 13 351 MUX2_X1
* cell instance $247 r0 *1 22.04,18.2
X$247 124 173 10 5 13 253 MUX2_X1
* cell instance $248 r0 *1 22.99,15.4
X$248 156 173 59 5 13 169 MUX2_X1
* cell instance $249 r0 *1 35.53,12.6
X$249 59 36 127 5 13 129 MUX2_X1
* cell instance $250 r0 *1 24.32,15.4
X$250 155 173 7 5 13 198 MUX2_X1
* cell instance $251 r0 *1 24.32,18.2
X$251 59 174 208 5 13 221 MUX2_X1
* cell instance $252 r0 *1 17.29,18.2
X$252 206 173 75 5 13 225 MUX2_X1
* cell instance $253 r0 *1 11.59,18.2
X$253 8 174 216 5 13 246 MUX2_X1
* cell instance $254 r0 *1 12.73,15.4
X$254 151 173 8 5 13 150 MUX2_X1
* cell instance $255 r0 *1 15.39,18.2
X$255 152 173 15 5 13 247 MUX2_X1
* cell instance $256 r0 *1 13.11,4.2
X$256 8 46 19 5 13 14 MUX2_X1
* cell instance $257 r0 *1 14.44,4.2
X$257 15 46 20 5 13 31 MUX2_X1
* cell instance $258 r0 *1 34.01,9.8
X$258 7 36 85 5 13 92 MUX2_X1
* cell instance $259 r0 *1 31.35,12.6
X$259 59 140 126 5 13 132 MUX2_X1
* cell instance $260 r0 *1 24.51,23.8
X$260 269 94 280 5 13 328 MUX2_X1
* cell instance $261 r0 *1 31.92,4.2
X$261 7 46 24 5 13 48 MUX2_X1
* cell instance $262 r0 *1 7.41,15.4
X$262 15 140 170 5 13 181 MUX2_X1
* cell instance $263 r0 *1 8.55,18.2
X$263 15 174 202 5 13 245 MUX2_X1
* cell instance $264 r0 *1 24.89,29.4
X$264 269 174 376 5 13 372 MUX2_X1
* cell instance $265 r0 *1 31.92,32.2
X$265 269 140 406 5 13 405 MUX2_X1
* cell instance $266 r0 *1 31.54,7
X$266 59 46 60 5 13 62 MUX2_X1
* cell instance $338 m0 *1 13.68,23.8
X$338 277 272 278 13 5 273 HA_X1
* cell instance $339 m0 *1 15.58,23.8
X$339 277 5 13 279 INV_X4
* cell instance $388 m0 *1 10.07,32.2
X$388 173 393 5 13 364 XNOR2_X2
* cell instance $531 r0 *1 17.29,4.2
X$531 21 18 34 5 51 13 AOI21_X1
* cell instance $570 m0 *1 8.93,4.2
X$570 15 36 17 5 13 27 MUX2_X1
* cell instance $643 m0 *1 39.52,18.2
X$643 77 210 211 13 179 5 OAI21_X1
* cell instance $644 m0 *1 18.43,18.2
X$644 206 112 218 13 197 5 OAI21_X1
* cell instance $645 m0 *1 28.31,26.6
X$645 16 283 282 13 304 5 OAI21_X1
* cell instance $646 m0 *1 19.38,9.8
X$646 16 76 70 13 74 5 OAI21_X1
* cell instance $647 m0 *1 18.05,40.6
X$647 457 459 470 13 455 5 OAI21_X1
* cell instance $648 m0 *1 19.57,7
X$648 16 41 66 13 52 5 OAI21_X1
* cell instance $649 m0 *1 11.4,12.6
X$649 111 112 53 13 166 5 OAI21_X1
* cell instance $650 m0 *1 13.68,12.6
X$650 80 112 81 13 113 5 OAI21_X1
* cell instance $651 m0 *1 15.39,7
X$651 19 18 40 13 54 5 OAI21_X1
* cell instance $652 m0 *1 21.66,4.2
X$652 16 22 30 13 32 5 OAI21_X1
* cell instance $653 m0 *1 32.68,37.8
X$653 172 420 349 13 427 5 OAI21_X1
* cell instance $654 m0 *1 16.72,15.4
X$654 151 112 137 13 168 5 OAI21_X1
* cell instance $655 m0 *1 26.6,7
X$655 16 57 56 13 44 5 OAI21_X1
* cell instance $656 m0 *1 25.84,15.4
X$656 155 112 125 13 142 5 OAI21_X1
* cell instance $657 m0 *1 31.35,9.8
X$657 77 78 95 13 97 5 OAI21_X1
* cell instance $658 r0 *1 40.66,26.6
X$658 77 321 343 13 287 5 OAI21_X1
* cell instance $659 r0 *1 38.95,26.6
X$659 77 320 346 13 300 5 OAI21_X1
* cell instance $660 r0 *1 15.77,4.2
X$660 20 18 51 13 50 5 OAI21_X1
* cell instance $661 r0 *1 27.74,1.4
X$661 16 12 11 13 29 5 OAI21_X1
* cell instance $662 r0 *1 8.36,29.4
X$662 308 364 384 13 383 5 OAI21_X1
* cell instance $663 r0 *1 30.02,9.8
X$663 99 18 84 13 158 5 OAI21_X1
* cell instance $664 r0 *1 30.4,7
X$664 60 18 64 13 58 5 OAI21_X1
* cell instance $665 r0 *1 31.16,37.8
X$665 172 451 454 13 452 5 OAI21_X1
* cell instance $666 r0 *1 10.64,9.8
X$666 79 112 101 13 110 5 OAI21_X1
* cell instance $667 r0 *1 29.26,15.4
X$667 112 156 157 13 196 5 OAI21_X1
* cell instance $668 r0 *1 17.67,9.8
X$668 69 18 82 13 103 5 OAI21_X1
* cell instance $669 r0 *1 31.16,18.2
X$669 226 112 235 13 223 5 OAI21_X1
* cell instance $670 r0 *1 24.32,12.6
X$670 124 112 133 13 145 5 OAI21_X1
* cell instance $671 r0 *1 15.77,15.4
X$671 152 112 146 13 192 5 OAI21_X1
* cell instance $672 r0 *1 30.4,4.2
X$672 24 18 23 13 49 5 OAI21_X1
* cell instance $673 r0 *1 30.4,29.4
X$673 392 356 153 13 371 5 OAI21_X1
* cell instance $674 r0 *1 25.84,7
X$674 55 18 43 13 71 5 OAI21_X1
* cell instance $675 r0 *1 39.14,9.8
X$675 77 86 109 13 87 5 OAI21_X1
* cell instance $676 m0 *1 30.21,18.2
X$676 175 204 5 13 189 NAND2_X1
* cell instance $677 m0 *1 21.47,40.6
X$677 471 461 5 13 444 NAND2_X1
* cell instance $678 m0 *1 9.12,15.4
X$678 136 149 5 13 214 NAND2_X1
* cell instance $679 r0 *1 9.69,15.4
X$679 163 171 147 166 5 13 148 NAND4_X1
* cell instance $680 m0 *1 5.89,21
X$680 243 205 5 13 242 NAND2_X1
* cell instance $681 m0 *1 25.84,37.8
X$681 426 428 5 13 437 NAND2_X1
* cell instance $682 m0 *1 38.95,18.2
X$682 115 210 5 13 182 NAND2_X1
* cell instance $683 m0 *1 39.33,21
X$683 260 240 5 13 233 NAND2_X1
* cell instance $684 m0 *1 19,7
X$684 8 16 5 13 66 NAND2_X1
* cell instance $685 m0 *1 21.09,9.8
X$685 75 16 5 13 70 NAND2_X1
* cell instance $686 m0 *1 30.59,23.8
X$686 270 112 5 13 257 NAND2_X1
* cell instance $687 m0 *1 28.69,23.8
X$687 269 16 5 13 282 NAND2_X1
* cell instance $688 m0 *1 39.9,21
X$688 241 240 5 13 244 NAND2_X1
* cell instance $689 m0 *1 38.76,21
X$689 244 194 5 13 288 NAND2_X1
* cell instance $690 m0 *1 40.28,18.2
X$690 59 77 5 13 211 NAND2_X1
* cell instance $691 m0 *1 29.26,23.8
X$691 115 283 5 13 256 NAND2_X1
* cell instance $692 m0 *1 22.99,40.6
X$692 445 446 5 13 448 NAND2_X1
* cell instance $693 m0 *1 38,12.6
X$693 115 86 5 13 108 NAND2_X1
* cell instance $694 m0 *1 27.17,23.8
X$694 293 204 5 13 281 NAND2_X1
* cell instance $695 m0 *1 30.21,29.4
X$695 337 204 5 13 350 NAND2_X1
* cell instance $696 m0 *1 20.33,37.8
X$696 430 435 5 13 424 NAND2_X1
* cell instance $697 m0 *1 20.14,40.6
X$697 443 424 5 13 460 NAND2_X1
* cell instance $698 m0 *1 19.38,29.4
X$698 367 305 5 13 140 NAND2_X1
* cell instance $699 m0 *1 6.84,23.8
X$699 268 240 5 13 262 NAND2_X1
* cell instance $700 m0 *1 20.14,29.4
X$700 368 305 5 13 94 NAND2_X1
* cell instance $701 m0 *1 15.58,35
X$701 415 401 5 13 410 NAND2_X1
* cell instance $702 m0 *1 5.13,21
X$702 237 240 5 13 243 NAND2_X1
* cell instance $703 m0 *1 29.64,9.8
X$703 10 77 5 13 95 NAND2_X1
* cell instance $704 m0 *1 9.12,29.4
X$704 174 314 5 13 355 NAND2_X1
* cell instance $705 m0 *1 8.55,29.4
X$705 354 355 5 13 310 NAND2_X1
* cell instance $706 m0 *1 7.22,29.4
X$706 352 353 5 13 330 NAND2_X1
* cell instance $707 m0 *1 7.98,29.4
X$707 364 309 5 13 344 NAND2_X1
* cell instance $708 m0 *1 14.06,29.4
X$708 296 333 5 13 348 NAND2_X1
* cell instance $709 m0 *1 20.52,26.6
X$709 299 305 5 13 46 NAND2_X1
* cell instance $710 r0 *1 26.6,35
X$710 411 413 5 13 428 NAND2_X1
* cell instance $711 r0 *1 38.38,26.6
X$711 115 320 5 13 342 NAND2_X1
* cell instance $712 r0 *1 19.95,40.6
X$712 458 460 5 13 461 NAND2_X1
* cell instance $713 r0 *1 13.3,18.2
X$713 216 204 5 13 217 NAND2_X1
* cell instance $714 r0 *1 21.28,37.8
X$714 442 431 5 13 435 NAND2_X1
* cell instance $715 r0 *1 21.85,37.8
X$715 147 456 240 13 5 442 OAI21_X2
* cell instance $716 r0 *1 23.18,37.8
X$716 441 447 5 13 445 NAND2_X1
* cell instance $717 r0 *1 35.72,18.2
X$717 234 185 5 13 228 NAND2_X1
* cell instance $718 r0 *1 41.42,26.6
X$718 269 77 5 13 343 NAND2_X1
* cell instance $719 r0 *1 36.86,18.2
X$719 233 190 5 13 229 NAND2_X1
* cell instance $720 r0 *1 26.79,23.8
X$720 149 280 5 13 274 NAND2_X1
* cell instance $721 r0 *1 33.06,15.4
X$721 126 149 5 13 176 NAND2_X1
* cell instance $722 r0 *1 10.45,18.2
X$722 255 204 5 13 203 NAND2_X1
* cell instance $723 r0 *1 24.89,37.8
X$723 440 450 5 13 447 NAND2_X1
* cell instance $724 r0 *1 37.43,18.2
X$724 230 240 5 13 234 NAND2_X1
* cell instance $725 r0 *1 8.74,26.6
X$725 345 310 5 13 309 NAND2_X1
* cell instance $726 r0 *1 34.39,15.4
X$726 159 149 5 13 160 NAND2_X1
* cell instance $727 r0 *1 26.22,29.4
X$727 376 204 5 13 390 NAND2_X1
* cell instance $728 r0 *1 11.78,15.4
X$728 165 149 5 13 187 NAND2_X1
* cell instance $729 r0 *1 24.51,35
X$729 403 172 5 13 413 NAND2_X1
* cell instance $730 r0 *1 38.57,9.8
X$730 7 77 5 13 109 NAND2_X1
* cell instance $731 r0 *1 25.27,35
X$731 21 240 5 13 411 NAND2_X1
* cell instance $732 r0 *1 28.5,1.4
X$732 7 16 5 13 11 NAND2_X1
* cell instance $733 r0 *1 8.74,15.4
X$733 170 149 5 13 163 NAND2_X1
* cell instance $734 r0 *1 34.2,32.2
X$734 149 406 5 13 408 NAND2_X1
* cell instance $735 r0 *1 9.88,18.2
X$735 202 204 5 13 171 NAND2_X1
* cell instance $736 r0 *1 22.8,4.2
X$736 10 16 5 13 30 NAND2_X1
* cell instance $737 r0 *1 20.14,29.4
X$737 305 336 5 13 36 NAND2_X1
* cell instance $738 r0 *1 7.41,18.2
X$738 201 213 5 13 212 NAND2_X1
* cell instance $739 r0 *1 32.87,29.4
X$739 149 378 5 13 370 NAND2_X1
* cell instance $740 r0 *1 29.45,26.6
X$740 317 204 5 13 325 NAND2_X1
* cell instance $741 r0 *1 26.6,7
X$741 59 16 5 13 56 NAND2_X1
* cell instance $742 r0 *1 7.03,21
X$742 262 164 5 13 263 NAND2_X1
* cell instance $743 r0 *1 40.09,29.4
X$743 115 321 5 13 363 NAND2_X1
* cell instance $744 r0 *1 28.88,18.2
X$744 208 204 5 13 219 NAND2_X1
* cell instance $745 r0 *1 39.71,26.6
X$745 316 77 5 13 346 NAND2_X1
* cell instance $746 r0 *1 25.46,37.8
X$746 436 437 5 13 450 NAND2_X1
* cell instance $747 r0 *1 12.54,26.6
X$747 296 313 5 13 314 NAND2_X1
* cell instance $748 r0 *1 6.65,18.2
X$748 200 240 5 13 201 NAND2_X1
* cell instance $749 m0 *1 5.32,12.6
X$749 5 111 117 28 13 DFF_X1
* cell instance $750 m0 *1 38.95,9.8
X$750 5 88 87 25 13 DFF_X1
* cell instance $751 m0 *1 12.35,15.4
X$751 5 151 150 28 13 DFF_X1
* cell instance $752 m0 *1 16.53,21
X$752 5 206 225 238 13 DFF_X1
* cell instance $753 m0 *1 38.19,23.8
X$753 5 241 288 259 13 DFF_X1
* cell instance $754 m0 *1 13.68,4.2
X$754 5 20 31 6 13 DFF_X1
* cell instance $755 m0 *1 27.36,4.2
X$755 5 26 29 45 13 DFF_X1
* cell instance $756 m0 *1 21.47,12.6
X$756 5 106 120 45 13 DFF_X1
* cell instance $757 m0 *1 33.63,23.8
X$757 5 289 290 239 13 DFF_X1
* cell instance $758 m0 *1 38,26.6
X$758 5 322 300 239 13 DFF_X1
* cell instance $759 m0 *1 6.46,21
X$759 5 202 245 323 13 DFF_X1
* cell instance $760 m0 *1 22.42,4.2
X$760 5 33 32 45 13 DFF_X1
* cell instance $761 m0 *1 26.22,9.8
X$761 5 99 100 45 13 DFF_X1
* cell instance $762 m0 *1 21.09,18.2
X$762 5 155 198 45 13 DFF_X1
* cell instance $763 m0 *1 13.3,21
X$763 5 152 247 238 13 DFF_X1
* cell instance $764 m0 *1 10.07,21
X$764 5 216 246 238 13 DFF_X1
* cell instance $765 m0 *1 1.9,21
X$765 5 237 242 199 13 DFF_X1
* cell instance $766 m0 *1 33.44,32.2
X$766 5 378 386 239 13 DFF_X1
* cell instance $767 m0 *1 32.49,35
X$767 5 406 405 239 13 DFF_X1
* cell instance $768 m0 *1 10.45,4.2
X$768 5 17 27 28 13 DFF_X1
* cell instance $769 m0 *1 4.56,15.4
X$769 5 136 141 28 13 DFF_X1
* cell instance $770 m0 *1 27.36,7
X$770 5 65 44 45 13 DFF_X1
* cell instance $771 m0 *1 17.29,12.6
X$771 5 119 104 6 13 DFF_X1
* cell instance $772 m0 *1 31.54,21
X$772 5 248 249 239 13 DFF_X1
* cell instance $773 m0 *1 31.73,12.6
X$773 5 126 132 25 13 DFF_X1
* cell instance $774 m0 *1 33.25,15.4
X$774 5 159 162 25 13 DFF_X1
* cell instance $775 m0 *1 26.79,18.2
X$775 5 175 222 45 13 DFF_X1
* cell instance $776 m0 *1 26.41,21
X$776 5 226 254 252 13 DFF_X1
* cell instance $777 m0 *1 25.08,29.4
X$777 5 337 373 252 13 DFF_X1
* cell instance $778 m0 *1 22.04,15.4
X$778 5 156 169 45 13 DFF_X1
* cell instance $779 m0 *1 35.34,21
X$779 5 230 228 259 13 DFF_X1
* cell instance $780 m0 *1 23.56,26.6
X$780 5 280 328 252 13 DFF_X1
* cell instance $781 m0 *1 18.05,4.2
X$781 5 35 9 6 13 DFF_X1
* cell instance $782 m0 *1 21.28,4.2
X$782 35 5 13 34 INV_X1
* cell instance $783 m0 *1 30.4,40.6
X$783 5 474 452 259 13 DFF_X1
* cell instance $784 m0 *1 30.4,26.6
X$784 5 284 326 239 13 DFF_X1
* cell instance $785 m0 *1 27.74,32.2
X$785 5 399 377 252 13 DFF_X1
* cell instance $786 m0 *1 21.09,21
X$786 5 124 253 252 13 DFF_X1
* cell instance $787 r0 *1 4.18,15.4
X$787 5 170 181 28 13 DFF_X1
* cell instance $788 r0 *1 38.95,15.4
X$788 5 180 179 25 13 DFF_X1
* cell instance $789 r0 *1 3.42,18.2
X$789 5 200 212 199 13 DFF_X1
* cell instance $790 r0 *1 36.48,21
X$790 5 260 229 259 13 DFF_X1
* cell instance $791 r0 *1 21.28,23.8
X$791 5 293 275 252 13 DFF_X1
* cell instance $792 r0 *1 3.8,21
X$792 5 268 263 199 13 DFF_X1
* cell instance $793 r0 *1 21.66,29.4
X$793 5 376 372 252 13 DFF_X1
* cell instance $794 r0 *1 19,7
X$794 5 96 74 6 13 DFF_X1
* cell instance $795 r0 *1 16.53,15.4
X$795 5 139 191 6 13 DFF_X1
* cell instance $796 r0 *1 25.65,18.2
X$796 5 208 221 45 13 DFF_X1
* cell instance $797 r0 *1 8.93,12.6
X$797 5 165 128 28 13 DFF_X1
* cell instance $798 r0 *1 8.93,4.2
X$798 5 38 37 28 13 DFF_X1
* cell instance $799 r0 *1 12.16,4.2
X$799 17 18 5 13 39 NOR2_X1
* cell instance $800 r0 *1 10.45,7
X$800 5 73 72 28 13 DFF_X1
* cell instance $801 r0 *1 10.07,21
X$801 5 255 264 238 13 DFF_X1
* cell instance $802 r0 *1 38.38,32.2
X$802 5 380 395 239 13 DFF_X1
* cell instance $803 r0 *1 18.62,4.2
X$803 5 42 52 6 13 DFF_X1
* cell instance $804 r0 *1 12.54,9.8
X$804 5 80 90 6 13 DFF_X1
* cell instance $805 r0 *1 22.23,7
X$805 5 55 67 45 13 DFF_X1
* cell instance $806 r0 *1 27.55,12.6
X$806 5 130 135 45 13 DFF_X1
* cell instance $807 r0 *1 7.22,9.8
X$807 5 79 89 28 13 DFF_X1
* cell instance $808 r0 *1 32.87,7
X$808 5 60 62 25 13 DFF_X1
* cell instance $809 r0 *1 33.25,4.2
X$809 5 24 48 25 13 DFF_X1
* cell instance $810 r0 *1 31.92,37.8
X$810 5 453 427 259 13 DFF_X1
* cell instance $811 r0 *1 38.38,23.8
X$811 5 286 287 239 13 DFF_X1
* cell instance $812 r0 *1 35.34,9.8
X$812 5 85 92 25 13 DFF_X1
* cell instance $813 r0 *1 33.63,26.6
X$813 5 319 318 239 13 DFF_X1
* cell instance $814 r0 *1 15.58,7
X$814 5 69 68 6 13 DFF_X1
* cell instance $815 r0 *1 35.72,29.4
X$815 5 359 340 239 13 DFF_X1
* cell instance $816 r0 *1 30.78,9.8
X$816 5 93 97 25 13 DFF_X1
* cell instance $817 r0 *1 24.89,9.8
X$817 5 134 118 45 13 DFF_X1
* cell instance $818 r0 *1 27.55,23.8
X$818 5 292 304 252 13 DFF_X1
* cell instance $819 r0 *1 25.65,26.6
X$819 5 317 351 252 13 DFF_X1
* cell instance $820 r0 *1 18.24,21
X$820 5 251 265 238 13 DFF_X1
* cell instance $821 r0 *1 36.86,12.6
X$821 5 127 129 25 13 DFF_X1
* cell instance $856 r0 *1 12.73,1.4
X$856 5 19 14 6 13 DFF_X1
* cell instance $862 m0 *1 4.56,12.6
X$862 121 5 13 75 BUF_X1
* cell instance $863 m0 *1 39.71,29.4
X$863 361 5 13 316 BUF_X1
* cell instance $864 m0 *1 5.7,23.8
X$864 268 5 13 276 BUF_X1
* cell instance $865 m0 *1 6.08,26.6
X$865 294 5 13 301 BUF_X1
* cell instance $866 m0 *1 29.83,40.6
X$866 466 5 13 464 BUF_X1
* cell instance $867 m0 *1 41.42,21
X$867 241 5 13 231 BUF_X1
* cell instance $868 m0 *1 41.61,32.2
X$868 396 5 13 269 BUF_X1
* cell instance $869 m0 *1 28.88,12.6
X$869 115 5 13 18 BUF_X1
* cell instance $870 m0 *1 40.47,21
X$870 230 5 13 232 BUF_X1
* cell instance $871 r0 *1 40.28,7
X$871 61 5 13 59 BUF_X1
* cell instance $873 r0 *1 2.28,26.6
X$873 329 5 13 311 BUF_X1
* cell instance $874 r0 *1 3.23,21
X$874 237 5 13 267 BUF_X1
* cell instance $875 r0 *1 38.57,4.2
X$875 47 5 13 7 BUF_X1
* cell instance $876 r0 *1 2.28,18.2
X$876 200 5 13 224 BUF_X1
* cell instance $877 r0 *1 19.38,40.6
X$877 404 5 13 303 BUF_X1
* cell instance $878 r0 *1 40.28,21
X$878 260 5 13 261 BUF_X1
* cell instance $879 r0 *1 33.63,40.6
X$879 453 5 13 468 BUF_X1
* cell instance $880 r0 *1 30.97,40.6
X$880 474 5 13 467 BUF_X1
* cell instance $881 r0 *1 28.88,40.6
X$881 473 5 13 465 BUF_X1
* cell instance $883 r0 *1 27.93,40.6
X$883 463 5 13 404 BUF_X1
* cell instance $1088 r0 *1 11.21,23.8
X$1088 302 277 173 5 13 NOR2_X4
* cell instance $1089 r0 *1 12.92,23.8
X$1089 5 238 272 297 278 303 13 DFFR_X1
.ENDS async_fifo

* cell NAND3_X4
* pin A2
* pin A1
* pin A3
* pin VSS
* pin ZN
* pin NWELL,VDD
.SUBCKT NAND3_X4 1 2 3 4 5 6
* net 1 A2
* net 2 A1
* net 3 A3
* net 4 VSS
* net 5 ZN
* net 6 NWELL,VDD
* device instance $1 r0 *1 0.21,0.995 PMOS_VTL
M$1 5 3 6 6 PMOS_VTL L=0.05U W=2.52U AS=0.19845P AD=0.19845P PS=3.78U PD=3.78U
* device instance $2 r0 *1 0.4,0.995 PMOS_VTL
M$2 6 1 5 6 PMOS_VTL L=0.05U W=2.52U AS=0.1764P AD=0.1764P PS=3.08U PD=3.08U
* device instance $3 r0 *1 0.59,0.995 PMOS_VTL
M$3 5 2 6 6 PMOS_VTL L=0.05U W=2.52U AS=0.1764P AD=0.1764P PS=3.08U PD=3.08U
* device instance $13 r0 *1 0.21,0.2975 NMOS_VTL
M$13 13 3 4 4 NMOS_VTL L=0.05U W=0.415U AS=0.043575P AD=0.02905P PS=1.04U
+ PD=0.555U
* device instance $14 r0 *1 0.4,0.2975 NMOS_VTL
M$14 12 1 13 4 NMOS_VTL L=0.05U W=0.415U AS=0.02905P AD=0.02905P PS=0.555U
+ PD=0.555U
* device instance $15 r0 *1 0.59,0.2975 NMOS_VTL
M$15 5 2 12 4 NMOS_VTL L=0.05U W=0.415U AS=0.02905P AD=0.02905P PS=0.555U
+ PD=0.555U
* device instance $16 r0 *1 0.78,0.2975 NMOS_VTL
M$16 10 2 5 4 NMOS_VTL L=0.05U W=0.415U AS=0.02905P AD=0.02905P PS=0.555U
+ PD=0.555U
* device instance $17 r0 *1 0.97,0.2975 NMOS_VTL
M$17 8 1 10 4 NMOS_VTL L=0.05U W=0.415U AS=0.02905P AD=0.02905P PS=0.555U
+ PD=0.555U
* device instance $18 r0 *1 1.16,0.2975 NMOS_VTL
M$18 4 3 8 4 NMOS_VTL L=0.05U W=0.415U AS=0.02905P AD=0.02905P PS=0.555U
+ PD=0.555U
* device instance $19 r0 *1 1.35,0.2975 NMOS_VTL
M$19 9 3 4 4 NMOS_VTL L=0.05U W=0.415U AS=0.02905P AD=0.02905P PS=0.555U
+ PD=0.555U
* device instance $20 r0 *1 1.54,0.2975 NMOS_VTL
M$20 7 1 9 4 NMOS_VTL L=0.05U W=0.415U AS=0.02905P AD=0.02905P PS=0.555U
+ PD=0.555U
* device instance $21 r0 *1 1.73,0.2975 NMOS_VTL
M$21 5 2 7 4 NMOS_VTL L=0.05U W=0.415U AS=0.02905P AD=0.02905P PS=0.555U
+ PD=0.555U
* device instance $22 r0 *1 1.92,0.2975 NMOS_VTL
M$22 14 2 5 4 NMOS_VTL L=0.05U W=0.415U AS=0.02905P AD=0.02905P PS=0.555U
+ PD=0.555U
* device instance $23 r0 *1 2.11,0.2975 NMOS_VTL
M$23 11 1 14 4 NMOS_VTL L=0.05U W=0.415U AS=0.02905P AD=0.02905P PS=0.555U
+ PD=0.555U
* device instance $24 r0 *1 2.3,0.2975 NMOS_VTL
M$24 4 3 11 4 NMOS_VTL L=0.05U W=0.415U AS=0.02905P AD=0.043575P PS=0.555U
+ PD=1.04U
.ENDS NAND3_X4

* cell AND3_X2
* pin A1
* pin A2
* pin A3
* pin NWELL,VDD
* pin VSS
* pin ZN
.SUBCKT AND3_X2 1 2 3 5 6 7
* net 1 A1
* net 2 A2
* net 3 A3
* net 5 NWELL,VDD
* net 6 VSS
* net 7 ZN
* device instance $1 r0 *1 0.17,0.995 PMOS_VTL
M$1 5 1 4 5 PMOS_VTL L=0.05U W=0.63U AS=0.06615P AD=0.0441P PS=1.47U PD=0.77U
* device instance $2 r0 *1 0.36,0.995 PMOS_VTL
M$2 4 2 5 5 PMOS_VTL L=0.05U W=0.63U AS=0.0441P AD=0.0441P PS=0.77U PD=0.77U
* device instance $3 r0 *1 0.55,0.995 PMOS_VTL
M$3 5 3 4 5 PMOS_VTL L=0.05U W=0.63U AS=0.0441P AD=0.0441P PS=0.77U PD=0.77U
* device instance $4 r0 *1 0.74,0.995 PMOS_VTL
M$4 7 4 5 5 PMOS_VTL L=0.05U W=1.26U AS=0.0882P AD=0.11025P PS=1.54U PD=2.24U
* device instance $6 r0 *1 0.17,0.2975 NMOS_VTL
M$6 9 1 4 6 NMOS_VTL L=0.05U W=0.415U AS=0.043575P AD=0.02905P PS=1.04U
+ PD=0.555U
* device instance $7 r0 *1 0.36,0.2975 NMOS_VTL
M$7 8 2 9 6 NMOS_VTL L=0.05U W=0.415U AS=0.02905P AD=0.02905P PS=0.555U
+ PD=0.555U
* device instance $8 r0 *1 0.55,0.2975 NMOS_VTL
M$8 6 3 8 6 NMOS_VTL L=0.05U W=0.415U AS=0.02905P AD=0.02905P PS=0.555U
+ PD=0.555U
* device instance $9 r0 *1 0.74,0.2975 NMOS_VTL
M$9 7 4 6 6 NMOS_VTL L=0.05U W=0.83U AS=0.0581P AD=0.072625P PS=1.11U PD=1.595U
.ENDS AND3_X2

* cell NAND3_X2
* pin A3
* pin A2
* pin A1
* pin VSS
* pin NWELL,VDD
* pin ZN
.SUBCKT NAND3_X2 1 2 3 4 5 6
* net 1 A3
* net 2 A2
* net 3 A1
* net 4 VSS
* net 5 NWELL,VDD
* net 6 ZN
* device instance $1 r0 *1 0.21,0.995 PMOS_VTL
M$1 6 1 5 5 PMOS_VTL L=0.05U W=1.26U AS=0.11025P AD=0.11025P PS=2.24U PD=2.24U
* device instance $2 r0 *1 0.4,0.995 PMOS_VTL
M$2 5 2 6 5 PMOS_VTL L=0.05U W=1.26U AS=0.0882P AD=0.0882P PS=1.54U PD=1.54U
* device instance $3 r0 *1 0.59,0.995 PMOS_VTL
M$3 6 3 5 5 PMOS_VTL L=0.05U W=1.26U AS=0.0882P AD=0.0882P PS=1.54U PD=1.54U
* device instance $7 r0 *1 0.21,0.2975 NMOS_VTL
M$7 10 1 4 4 NMOS_VTL L=0.05U W=0.415U AS=0.043575P AD=0.02905P PS=1.04U
+ PD=0.555U
* device instance $8 r0 *1 0.4,0.2975 NMOS_VTL
M$8 9 2 10 4 NMOS_VTL L=0.05U W=0.415U AS=0.02905P AD=0.02905P PS=0.555U
+ PD=0.555U
* device instance $9 r0 *1 0.59,0.2975 NMOS_VTL
M$9 6 3 9 4 NMOS_VTL L=0.05U W=0.415U AS=0.02905P AD=0.02905P PS=0.555U
+ PD=0.555U
* device instance $10 r0 *1 0.78,0.2975 NMOS_VTL
M$10 8 3 6 4 NMOS_VTL L=0.05U W=0.415U AS=0.02905P AD=0.02905P PS=0.555U
+ PD=0.555U
* device instance $11 r0 *1 0.97,0.2975 NMOS_VTL
M$11 7 2 8 4 NMOS_VTL L=0.05U W=0.415U AS=0.02905P AD=0.02905P PS=0.555U
+ PD=0.555U
* device instance $12 r0 *1 1.16,0.2975 NMOS_VTL
M$12 4 1 7 4 NMOS_VTL L=0.05U W=0.415U AS=0.02905P AD=0.043575P PS=0.555U
+ PD=1.04U
.ENDS NAND3_X2

* cell NAND2_X2
* pin A2
* pin A1
* pin VSS
* pin NWELL,VDD
* pin ZN
.SUBCKT NAND2_X2 1 2 3 4 5
* net 1 A2
* net 2 A1
* net 3 VSS
* net 4 NWELL,VDD
* net 5 ZN
* device instance $1 r0 *1 0.195,0.995 PMOS_VTL
M$1 5 1 4 4 PMOS_VTL L=0.05U W=1.26U AS=0.11025P AD=0.11025P PS=2.24U PD=2.24U
* device instance $2 r0 *1 0.385,0.995 PMOS_VTL
M$2 4 2 5 4 PMOS_VTL L=0.05U W=1.26U AS=0.0882P AD=0.0882P PS=1.54U PD=1.54U
* device instance $5 r0 *1 0.195,0.2975 NMOS_VTL
M$5 7 1 3 3 NMOS_VTL L=0.05U W=0.415U AS=0.043575P AD=0.02905P PS=1.04U
+ PD=0.555U
* device instance $6 r0 *1 0.385,0.2975 NMOS_VTL
M$6 5 2 7 3 NMOS_VTL L=0.05U W=0.415U AS=0.02905P AD=0.02905P PS=0.555U
+ PD=0.555U
* device instance $7 r0 *1 0.575,0.2975 NMOS_VTL
M$7 6 2 5 3 NMOS_VTL L=0.05U W=0.415U AS=0.02905P AD=0.02905P PS=0.555U
+ PD=0.555U
* device instance $8 r0 *1 0.765,0.2975 NMOS_VTL
M$8 3 1 6 3 NMOS_VTL L=0.05U W=0.415U AS=0.02905P AD=0.043575P PS=0.555U
+ PD=1.04U
.ENDS NAND2_X2

* cell XNOR2_X1
* pin A
* pin B
* pin NWELL,VDD
* pin VSS
* pin ZN
.SUBCKT XNOR2_X1 1 2 4 5 7
* net 1 A
* net 2 B
* net 4 NWELL,VDD
* net 5 VSS
* net 7 ZN
* device instance $1 r0 *1 0.18,1.1525 PMOS_VTL
M$1 3 1 4 4 PMOS_VTL L=0.05U W=0.315U AS=0.033075P AD=0.02205P PS=0.84U
+ PD=0.455U
* device instance $2 r0 *1 0.37,1.1525 PMOS_VTL
M$2 3 2 4 4 PMOS_VTL L=0.05U W=0.315U AS=0.0338625P AD=0.02205P PS=0.775U
+ PD=0.455U
* device instance $3 r0 *1 0.565,0.995 PMOS_VTL
M$3 7 3 4 4 PMOS_VTL L=0.05U W=0.63U AS=0.0338625P AD=0.0441P PS=0.775U PD=0.77U
* device instance $4 r0 *1 0.755,0.995 PMOS_VTL
M$4 8 1 7 4 PMOS_VTL L=0.05U W=0.63U AS=0.0441P AD=0.0441P PS=0.77U PD=0.77U
* device instance $5 r0 *1 0.945,0.995 PMOS_VTL
M$5 4 2 8 4 PMOS_VTL L=0.05U W=0.63U AS=0.0441P AD=0.06615P PS=0.77U PD=1.47U
* device instance $6 r0 *1 0.18,0.195 NMOS_VTL
M$6 9 1 3 5 NMOS_VTL L=0.05U W=0.21U AS=0.02205P AD=0.0147P PS=0.63U PD=0.35U
* device instance $7 r0 *1 0.37,0.195 NMOS_VTL
M$7 5 2 9 5 NMOS_VTL L=0.05U W=0.21U AS=0.0147P AD=0.0224P PS=0.35U PD=0.56U
* device instance $8 r0 *1 0.565,0.2975 NMOS_VTL
M$8 6 3 5 5 NMOS_VTL L=0.05U W=0.415U AS=0.0224P AD=0.02905P PS=0.56U PD=0.555U
* device instance $9 r0 *1 0.755,0.2975 NMOS_VTL
M$9 7 1 6 5 NMOS_VTL L=0.05U W=0.415U AS=0.02905P AD=0.02905P PS=0.555U
+ PD=0.555U
* device instance $10 r0 *1 0.945,0.2975 NMOS_VTL
M$10 6 2 7 5 NMOS_VTL L=0.05U W=0.415U AS=0.02905P AD=0.043575P PS=0.555U
+ PD=1.04U
.ENDS XNOR2_X1

* cell XNOR2_X2
* pin A
* pin B
* pin VSS
* pin NWELL,VDD
* pin ZN
.SUBCKT XNOR2_X2 2 3 4 5 7
* net 2 A
* net 3 B
* net 4 VSS
* net 5 NWELL,VDD
* net 7 ZN
* device instance $1 r0 *1 1.135,0.995 PMOS_VTL
M$1 7 2 8 5 PMOS_VTL L=0.05U W=0.63U AS=0.06615P AD=0.0441P PS=1.47U PD=0.77U
* device instance $2 r0 *1 1.325,0.995 PMOS_VTL
M$2 9 2 7 5 PMOS_VTL L=0.05U W=0.63U AS=0.0441P AD=0.0441P PS=0.77U PD=0.77U
* device instance $3 r0 *1 1.515,0.995 PMOS_VTL
M$3 5 3 9 5 PMOS_VTL L=0.05U W=0.63U AS=0.0441P AD=0.0441P PS=0.77U PD=0.77U
* device instance $4 r0 *1 1.705,0.995 PMOS_VTL
M$4 8 3 5 5 PMOS_VTL L=0.05U W=0.63U AS=0.0441P AD=0.06615P PS=0.77U PD=1.47U
* device instance $5 r0 *1 0.18,0.995 PMOS_VTL
M$5 7 1 5 5 PMOS_VTL L=0.05U W=1.26U AS=0.11025P AD=0.0882P PS=2.24U PD=1.54U
* device instance $7 r0 *1 0.56,0.995 PMOS_VTL
M$7 1 3 5 5 PMOS_VTL L=0.05U W=0.63U AS=0.0441P AD=0.0441P PS=0.77U PD=0.77U
* device instance $8 r0 *1 0.75,0.995 PMOS_VTL
M$8 5 2 1 5 PMOS_VTL L=0.05U W=0.63U AS=0.0441P AD=0.06615P PS=0.77U PD=1.47U
* device instance $9 r0 *1 1.135,0.2975 NMOS_VTL
M$9 6 2 7 4 NMOS_VTL L=0.05U W=0.83U AS=0.072625P AD=0.0581P PS=1.595U PD=1.11U
* device instance $11 r0 *1 1.515,0.2975 NMOS_VTL
M$11 6 3 7 4 NMOS_VTL L=0.05U W=0.83U AS=0.0581P AD=0.072625P PS=1.11U PD=1.595U
* device instance $13 r0 *1 0.18,0.2975 NMOS_VTL
M$13 6 1 4 4 NMOS_VTL L=0.05U W=0.83U AS=0.072625P AD=0.0581P PS=1.595U PD=1.11U
* device instance $15 r0 *1 0.56,0.2975 NMOS_VTL
M$15 10 3 4 4 NMOS_VTL L=0.05U W=0.415U AS=0.02905P AD=0.02905P PS=0.555U
+ PD=0.555U
* device instance $16 r0 *1 0.75,0.2975 NMOS_VTL
M$16 1 2 10 4 NMOS_VTL L=0.05U W=0.415U AS=0.02905P AD=0.043575P PS=0.555U
+ PD=1.04U
.ENDS XNOR2_X2

* cell NOR2_X4
* pin A2
* pin A1
* pin ZN
* pin VSS
* pin NWELL,VDD
.SUBCKT NOR2_X4 1 2 3 4 5
* net 1 A2
* net 2 A1
* net 3 ZN
* net 4 VSS
* net 5 NWELL,VDD
* device instance $1 r0 *1 0.21,0.995 PMOS_VTL
M$1 9 1 5 5 PMOS_VTL L=0.05U W=0.63U AS=0.06615P AD=0.0441P PS=1.47U PD=0.77U
* device instance $2 r0 *1 0.4,0.995 PMOS_VTL
M$2 3 2 9 5 PMOS_VTL L=0.05U W=0.63U AS=0.0441P AD=0.0441P PS=0.77U PD=0.77U
* device instance $3 r0 *1 0.59,0.995 PMOS_VTL
M$3 8 2 3 5 PMOS_VTL L=0.05U W=0.63U AS=0.0441P AD=0.0441P PS=0.77U PD=0.77U
* device instance $4 r0 *1 0.78,0.995 PMOS_VTL
M$4 5 1 8 5 PMOS_VTL L=0.05U W=0.63U AS=0.0441P AD=0.0441P PS=0.77U PD=0.77U
* device instance $5 r0 *1 0.97,0.995 PMOS_VTL
M$5 7 1 5 5 PMOS_VTL L=0.05U W=0.63U AS=0.0441P AD=0.0441P PS=0.77U PD=0.77U
* device instance $6 r0 *1 1.16,0.995 PMOS_VTL
M$6 3 2 7 5 PMOS_VTL L=0.05U W=0.63U AS=0.0441P AD=0.0441P PS=0.77U PD=0.77U
* device instance $7 r0 *1 1.35,0.995 PMOS_VTL
M$7 6 2 3 5 PMOS_VTL L=0.05U W=0.63U AS=0.0441P AD=0.0441P PS=0.77U PD=0.77U
* device instance $8 r0 *1 1.54,0.995 PMOS_VTL
M$8 5 1 6 5 PMOS_VTL L=0.05U W=0.63U AS=0.0441P AD=0.06615P PS=0.77U PD=1.47U
* device instance $9 r0 *1 0.21,0.2975 NMOS_VTL
M$9 3 1 4 4 NMOS_VTL L=0.05U W=1.66U AS=0.130725P AD=0.130725P PS=2.705U
+ PD=2.705U
* device instance $10 r0 *1 0.4,0.2975 NMOS_VTL
M$10 4 2 3 4 NMOS_VTL L=0.05U W=1.66U AS=0.1162P AD=0.1162P PS=2.22U PD=2.22U
.ENDS NOR2_X4

* cell AOI21_X1
* pin A
* pin B2
* pin B1
* pin VSS
* pin ZN
* pin NWELL,VDD
.SUBCKT AOI21_X1 1 2 3 4 6 7
* net 1 A
* net 2 B2
* net 3 B1
* net 4 VSS
* net 6 ZN
* net 7 NWELL,VDD
* device instance $1 r0 *1 0.21,0.995 PMOS_VTL
M$1 6 2 5 7 PMOS_VTL L=0.05U W=0.63U AS=0.06615P AD=0.0441P PS=1.47U PD=0.77U
* device instance $2 r0 *1 0.4,0.995 PMOS_VTL
M$2 5 3 6 7 PMOS_VTL L=0.05U W=0.63U AS=0.0441P AD=0.0441P PS=0.77U PD=0.77U
* device instance $3 r0 *1 0.59,0.995 PMOS_VTL
M$3 7 1 5 7 PMOS_VTL L=0.05U W=0.63U AS=0.0441P AD=0.06615P PS=0.77U PD=1.47U
* device instance $4 r0 *1 0.21,0.2975 NMOS_VTL
M$4 8 2 4 4 NMOS_VTL L=0.05U W=0.415U AS=0.043575P AD=0.02905P PS=1.04U
+ PD=0.555U
* device instance $5 r0 *1 0.4,0.2975 NMOS_VTL
M$5 6 3 8 4 NMOS_VTL L=0.05U W=0.415U AS=0.02905P AD=0.02905P PS=0.555U
+ PD=0.555U
* device instance $6 r0 *1 0.59,0.2975 NMOS_VTL
M$6 4 1 6 4 NMOS_VTL L=0.05U W=0.415U AS=0.02905P AD=0.043575P PS=0.555U
+ PD=1.04U
.ENDS AOI21_X1

* cell INV_X4
* pin A
* pin VSS
* pin NWELL,VDD
* pin ZN
.SUBCKT INV_X4 1 2 3 4
* net 1 A
* net 2 VSS
* net 3 NWELL,VDD
* net 4 ZN
* device instance $1 r0 *1 0.17,0.995 PMOS_VTL
M$1 4 1 3 3 PMOS_VTL L=0.05U W=2.52U AS=0.19845P AD=0.19845P PS=3.78U PD=3.78U
* device instance $5 r0 *1 0.17,0.2975 NMOS_VTL
M$5 4 1 2 2 NMOS_VTL L=0.05U W=1.66U AS=0.130725P AD=0.130725P PS=2.705U
+ PD=2.705U
.ENDS INV_X4

* cell DFFS_X1
* pin VSS
* pin QN
* pin Q
* pin D
* pin CK
* pin SN
* pin NWELL,VDD
.SUBCKT DFFS_X1 1 7 8 13 15 16 19
* net 1 VSS
* net 7 QN
* net 8 Q
* net 13 D
* net 15 CK
* net 16 SN
* net 19 NWELL,VDD
* device instance $1 r0 *1 3.325,0.995 PMOS_VTL
M$1 19 5 7 19 PMOS_VTL L=0.05U W=0.63U AS=0.06615P AD=0.0441P PS=1.47U PD=0.77U
* device instance $2 r0 *1 3.515,0.995 PMOS_VTL
M$2 8 6 19 19 PMOS_VTL L=0.05U W=0.63U AS=0.0441P AD=0.06615P PS=0.77U PD=1.47U
* device instance $3 r0 *1 0.75,1.015 PMOS_VTL
M$3 22 2 4 19 PMOS_VTL L=0.05U W=0.09U AS=0.0183P AD=0.0072P PS=0.57U PD=0.25U
* device instance $4 r0 *1 0.96,1.015 PMOS_VTL
M$4 22 14 19 19 PMOS_VTL L=0.05U W=0.09U AS=0.01485P AD=0.0072P PS=0.47U
+ PD=0.25U
* device instance $5 r0 *1 1.165,0.9025 PMOS_VTL
M$5 14 16 19 19 PMOS_VTL L=0.05U W=0.315U AS=0.01485P AD=0.02205P PS=0.47U
+ PD=0.455U
* device instance $6 r0 *1 1.355,0.9025 PMOS_VTL
M$6 19 4 14 19 PMOS_VTL L=0.05U W=0.315U AS=0.02205P AD=0.02205P PS=0.455U
+ PD=0.455U
* device instance $7 r0 *1 1.545,0.9025 PMOS_VTL
M$7 2 15 19 19 PMOS_VTL L=0.05U W=0.315U AS=0.02205P AD=0.033075P PS=0.455U
+ PD=0.84U
* device instance $8 r0 *1 0.17,1.0725 PMOS_VTL
M$8 3 2 19 19 PMOS_VTL L=0.05U W=0.315U AS=0.025725P AD=0.033075P PS=0.56U
+ PD=0.84U
* device instance $9 r0 *1 0.36,1.1 PMOS_VTL
M$9 21 13 19 19 PMOS_VTL L=0.05U W=0.42U AS=0.025725P AD=0.0294P PS=0.56U
+ PD=0.56U
* device instance $10 r0 *1 0.55,1.1 PMOS_VTL
M$10 4 3 21 19 PMOS_VTL L=0.05U W=0.42U AS=0.0294P AD=0.0183P PS=0.56U PD=0.57U
* device instance $11 r0 *1 1.885,0.9775 PMOS_VTL
M$11 23 4 19 19 PMOS_VTL L=0.05U W=0.315U AS=0.033075P AD=0.02205P PS=0.84U
+ PD=0.455U
* device instance $12 r0 *1 2.075,0.9775 PMOS_VTL
M$12 5 2 23 19 PMOS_VTL L=0.05U W=0.315U AS=0.02205P AD=0.014175P PS=0.455U
+ PD=0.455U
* device instance $13 r0 *1 2.265,1.09 PMOS_VTL
M$13 20 3 5 19 PMOS_VTL L=0.05U W=0.09U AS=0.014175P AD=0.0063P PS=0.455U
+ PD=0.23U
* device instance $14 r0 *1 2.455,1.09 PMOS_VTL
M$14 19 6 20 19 PMOS_VTL L=0.05U W=0.09U AS=0.0063P AD=0.0063P PS=0.23U PD=0.23U
* device instance $15 r0 *1 2.645,1.09 PMOS_VTL
M$15 20 16 19 19 PMOS_VTL L=0.05U W=0.09U AS=0.0063P AD=0.00945P PS=0.23U
+ PD=0.39U
* device instance $16 r0 *1 2.985,0.9775 PMOS_VTL
M$16 6 5 19 19 PMOS_VTL L=0.05U W=0.315U AS=0.033075P AD=0.033075P PS=0.84U
+ PD=0.84U
* device instance $17 r0 *1 3.325,0.2975 NMOS_VTL
M$17 1 5 7 1 NMOS_VTL L=0.05U W=0.415U AS=0.043575P AD=0.02905P PS=1.04U
+ PD=0.555U
* device instance $18 r0 *1 3.515,0.2975 NMOS_VTL
M$18 8 6 1 1 NMOS_VTL L=0.05U W=0.415U AS=0.02905P AD=0.043575P PS=0.555U
+ PD=1.04U
* device instance $19 r0 *1 2.265,0.315 NMOS_VTL
M$19 11 2 5 1 NMOS_VTL L=0.05U W=0.09U AS=0.0105P AD=0.0063P PS=0.35U PD=0.23U
* device instance $20 r0 *1 2.455,0.315 NMOS_VTL
M$20 10 6 11 1 NMOS_VTL L=0.05U W=0.09U AS=0.0063P AD=0.0063P PS=0.23U PD=0.23U
* device instance $21 r0 *1 2.645,0.315 NMOS_VTL
M$21 10 16 1 1 NMOS_VTL L=0.05U W=0.09U AS=0.01095P AD=0.0063P PS=0.36U PD=0.23U
* device instance $22 r0 *1 2.845,0.255 NMOS_VTL
M$22 6 5 1 1 NMOS_VTL L=0.05U W=0.21U AS=0.01095P AD=0.02205P PS=0.36U PD=0.63U
* device instance $23 r0 *1 1.695,0.375 NMOS_VTL
M$23 1 15 2 1 NMOS_VTL L=0.05U W=0.21U AS=0.02205P AD=0.0147P PS=0.63U PD=0.35U
* device instance $24 r0 *1 1.885,0.375 NMOS_VTL
M$24 18 4 1 1 NMOS_VTL L=0.05U W=0.21U AS=0.0147P AD=0.0147P PS=0.35U PD=0.35U
* device instance $25 r0 *1 2.075,0.375 NMOS_VTL
M$25 5 3 18 1 NMOS_VTL L=0.05U W=0.21U AS=0.0147P AD=0.0105P PS=0.35U PD=0.35U
* device instance $26 r0 *1 0.17,0.26 NMOS_VTL
M$26 3 2 1 1 NMOS_VTL L=0.05U W=0.21U AS=0.016975P AD=0.02205P PS=0.415U
+ PD=0.63U
* device instance $27 r0 *1 0.36,0.2275 NMOS_VTL
M$27 9 13 1 1 NMOS_VTL L=0.05U W=0.275U AS=0.016975P AD=0.01925P PS=0.415U
+ PD=0.415U
* device instance $28 r0 *1 0.55,0.2275 NMOS_VTL
M$28 4 2 9 1 NMOS_VTL L=0.05U W=0.275U AS=0.01925P AD=0.013225P PS=0.415U
+ PD=0.425U
* device instance $29 r0 *1 0.75,0.32 NMOS_VTL
M$29 12 3 4 1 NMOS_VTL L=0.05U W=0.09U AS=0.013225P AD=0.0072P PS=0.425U
+ PD=0.25U
* device instance $30 r0 *1 0.96,0.32 NMOS_VTL
M$30 12 14 1 1 NMOS_VTL L=0.05U W=0.09U AS=0.012225P AD=0.0072P PS=0.365U
+ PD=0.25U
* device instance $31 r0 *1 1.165,0.32 NMOS_VTL
M$31 17 16 1 1 NMOS_VTL L=0.05U W=0.21U AS=0.012225P AD=0.0147P PS=0.365U
+ PD=0.35U
* device instance $32 r0 *1 1.355,0.32 NMOS_VTL
M$32 14 4 17 1 NMOS_VTL L=0.05U W=0.21U AS=0.0147P AD=0.02205P PS=0.35U PD=0.63U
.ENDS DFFS_X1

* cell NOR2_X2
* pin A2
* pin A1
* pin VSS
* pin NWELL,VDD
* pin ZN
.SUBCKT NOR2_X2 1 2 3 4 5
* net 1 A2
* net 2 A1
* net 3 VSS
* net 4 NWELL,VDD
* net 5 ZN
* device instance $1 r0 *1 0.21,0.995 PMOS_VTL
M$1 7 1 4 4 PMOS_VTL L=0.05U W=0.63U AS=0.06615P AD=0.0441P PS=1.47U PD=0.77U
* device instance $2 r0 *1 0.4,0.995 PMOS_VTL
M$2 5 2 7 4 PMOS_VTL L=0.05U W=0.63U AS=0.0441P AD=0.0441P PS=0.77U PD=0.77U
* device instance $3 r0 *1 0.59,0.995 PMOS_VTL
M$3 6 2 5 4 PMOS_VTL L=0.05U W=0.63U AS=0.0441P AD=0.0441P PS=0.77U PD=0.77U
* device instance $4 r0 *1 0.78,0.995 PMOS_VTL
M$4 4 1 6 4 PMOS_VTL L=0.05U W=0.63U AS=0.0441P AD=0.06615P PS=0.77U PD=1.47U
* device instance $5 r0 *1 0.21,0.2975 NMOS_VTL
M$5 5 1 3 3 NMOS_VTL L=0.05U W=0.83U AS=0.072625P AD=0.072625P PS=1.595U
+ PD=1.595U
* device instance $6 r0 *1 0.4,0.2975 NMOS_VTL
M$6 3 2 5 3 NMOS_VTL L=0.05U W=0.83U AS=0.0581P AD=0.0581P PS=1.11U PD=1.11U
.ENDS NOR2_X2

* cell NAND2_X4
* pin A2
* pin A1
* pin VSS
* pin ZN
* pin NWELL,VDD
.SUBCKT NAND2_X4 1 2 4 5 6
* net 1 A2
* net 2 A1
* net 4 VSS
* net 5 ZN
* net 6 NWELL,VDD
* device instance $1 r0 *1 0.21,0.995 PMOS_VTL
M$1 5 1 6 6 PMOS_VTL L=0.05U W=2.52U AS=0.19845P AD=0.1764P PS=3.78U PD=3.08U
* device instance $5 r0 *1 0.97,0.995 PMOS_VTL
M$5 5 2 6 6 PMOS_VTL L=0.05U W=2.52U AS=0.1764P AD=0.19845P PS=3.08U PD=3.78U
* device instance $9 r0 *1 0.21,0.2975 NMOS_VTL
M$9 4 1 3 4 NMOS_VTL L=0.05U W=1.66U AS=0.130725P AD=0.1162P PS=2.705U PD=2.22U
* device instance $13 r0 *1 0.97,0.2975 NMOS_VTL
M$13 5 2 3 4 NMOS_VTL L=0.05U W=1.66U AS=0.1162P AD=0.130725P PS=2.22U PD=2.705U
.ENDS NAND2_X4

* cell NAND4_X1
* pin A4
* pin A3
* pin A2
* pin A1
* pin VSS
* pin NWELL,VDD
* pin ZN
.SUBCKT NAND4_X1 1 2 3 4 5 6 7
* net 1 A4
* net 2 A3
* net 3 A2
* net 4 A1
* net 5 VSS
* net 6 NWELL,VDD
* net 7 ZN
* device instance $1 r0 *1 0.17,0.995 PMOS_VTL
M$1 7 1 6 6 PMOS_VTL L=0.05U W=0.63U AS=0.06615P AD=0.0441P PS=1.47U PD=0.77U
* device instance $2 r0 *1 0.36,0.995 PMOS_VTL
M$2 6 2 7 6 PMOS_VTL L=0.05U W=0.63U AS=0.0441P AD=0.0441P PS=0.77U PD=0.77U
* device instance $3 r0 *1 0.55,0.995 PMOS_VTL
M$3 7 3 6 6 PMOS_VTL L=0.05U W=0.63U AS=0.0441P AD=0.0441P PS=0.77U PD=0.77U
* device instance $4 r0 *1 0.74,0.995 PMOS_VTL
M$4 6 4 7 6 PMOS_VTL L=0.05U W=0.63U AS=0.0441P AD=0.06615P PS=0.77U PD=1.47U
* device instance $5 r0 *1 0.17,0.2975 NMOS_VTL
M$5 10 1 5 5 NMOS_VTL L=0.05U W=0.415U AS=0.043575P AD=0.02905P PS=1.04U
+ PD=0.555U
* device instance $6 r0 *1 0.36,0.2975 NMOS_VTL
M$6 9 2 10 5 NMOS_VTL L=0.05U W=0.415U AS=0.02905P AD=0.02905P PS=0.555U
+ PD=0.555U
* device instance $7 r0 *1 0.55,0.2975 NMOS_VTL
M$7 8 3 9 5 NMOS_VTL L=0.05U W=0.415U AS=0.02905P AD=0.02905P PS=0.555U
+ PD=0.555U
* device instance $8 r0 *1 0.74,0.2975 NMOS_VTL
M$8 7 4 8 5 NMOS_VTL L=0.05U W=0.415U AS=0.02905P AD=0.043575P PS=0.555U
+ PD=1.04U
.ENDS NAND4_X1

* cell INV_X2
* pin A
* pin VSS
* pin NWELL,VDD
* pin ZN
.SUBCKT INV_X2 1 2 3 4
* net 1 A
* net 2 VSS
* net 3 NWELL,VDD
* net 4 ZN
* device instance $1 r0 *1 0.185,0.995 PMOS_VTL
M$1 4 1 3 3 PMOS_VTL L=0.05U W=1.26U AS=0.11025P AD=0.11025P PS=2.24U PD=2.24U
* device instance $3 r0 *1 0.185,0.2975 NMOS_VTL
M$3 4 1 2 2 NMOS_VTL L=0.05U W=0.83U AS=0.072625P AD=0.072625P PS=1.595U
+ PD=1.595U
.ENDS INV_X2

* cell NOR2_X1
* pin A2
* pin A1
* pin VSS
* pin NWELL,VDD
* pin ZN
.SUBCKT NOR2_X1 1 2 3 4 5
* net 1 A2
* net 2 A1
* net 3 VSS
* net 4 NWELL,VDD
* net 5 ZN
* device instance $1 r0 *1 0.185,0.995 PMOS_VTL
M$1 6 1 4 4 PMOS_VTL L=0.05U W=0.63U AS=0.06615P AD=0.0441P PS=1.47U PD=0.77U
* device instance $2 r0 *1 0.375,0.995 PMOS_VTL
M$2 5 2 6 4 PMOS_VTL L=0.05U W=0.63U AS=0.0441P AD=0.06615P PS=0.77U PD=1.47U
* device instance $3 r0 *1 0.185,0.2975 NMOS_VTL
M$3 5 1 3 3 NMOS_VTL L=0.05U W=0.415U AS=0.043575P AD=0.02905P PS=1.04U
+ PD=0.555U
* device instance $4 r0 *1 0.375,0.2975 NMOS_VTL
M$4 3 2 5 3 NMOS_VTL L=0.05U W=0.415U AS=0.02905P AD=0.043575P PS=0.555U
+ PD=1.04U
.ENDS NOR2_X1

* cell OR2_X1
* pin A1
* pin A2
* pin VSS
* pin NWELL,VDD
* pin ZN
.SUBCKT OR2_X1 1 2 3 5 6
* net 1 A1
* net 2 A2
* net 3 VSS
* net 5 NWELL,VDD
* net 6 ZN
* device instance $1 r0 *1 0.17,1.1525 PMOS_VTL
M$1 7 1 4 5 PMOS_VTL L=0.05U W=0.315U AS=0.033075P AD=0.02205P PS=0.84U
+ PD=0.455U
* device instance $2 r0 *1 0.36,1.1525 PMOS_VTL
M$2 7 2 5 5 PMOS_VTL L=0.05U W=0.315U AS=0.033075P AD=0.02205P PS=0.77U
+ PD=0.455U
* device instance $3 r0 *1 0.55,0.995 PMOS_VTL
M$3 6 4 5 5 PMOS_VTL L=0.05U W=0.63U AS=0.033075P AD=0.06615P PS=0.77U PD=1.47U
* device instance $4 r0 *1 0.17,0.195 NMOS_VTL
M$4 4 1 3 3 NMOS_VTL L=0.05U W=0.21U AS=0.02205P AD=0.0147P PS=0.63U PD=0.35U
* device instance $5 r0 *1 0.36,0.195 NMOS_VTL
M$5 3 2 4 3 NMOS_VTL L=0.05U W=0.21U AS=0.0147P AD=0.021875P PS=0.35U PD=0.555U
* device instance $6 r0 *1 0.55,0.2975 NMOS_VTL
M$6 6 4 3 3 NMOS_VTL L=0.05U W=0.415U AS=0.021875P AD=0.043575P PS=0.555U
+ PD=1.04U
.ENDS OR2_X1

* cell DFF_X1
* pin VSS
* pin Q
* pin D
* pin CK
* pin NWELL,VDD
.SUBCKT DFF_X1 1 9 14 15 16
* net 1 VSS
* net 8 QN
* net 9 Q
* net 14 D
* net 15 CK
* net 16 NWELL,VDD
* device instance $1 r0 *1 2.85,0.995 PMOS_VTL
M$1 16 6 8 16 PMOS_VTL L=0.05U W=0.63U AS=0.06615P AD=0.0441P PS=1.47U PD=0.77U
* device instance $2 r0 *1 3.04,0.995 PMOS_VTL
M$2 9 7 16 16 PMOS_VTL L=0.05U W=0.63U AS=0.0441P AD=0.06615P PS=0.77U PD=1.47U
* device instance $3 r0 *1 0.185,0.9425 PMOS_VTL
M$3 16 5 2 16 PMOS_VTL L=0.05U W=0.315U AS=0.033075P AD=0.014175P PS=0.84U
+ PD=0.455U
* device instance $4 r0 *1 0.375,1.055 PMOS_VTL
M$4 17 3 16 16 PMOS_VTL L=0.05U W=0.09U AS=0.014175P AD=0.0063P PS=0.455U
+ PD=0.23U
* device instance $5 r0 *1 0.565,1.055 PMOS_VTL
M$5 17 5 4 16 PMOS_VTL L=0.05U W=0.09U AS=0.018075P AD=0.0063P PS=0.565U
+ PD=0.23U
* device instance $6 r0 *1 0.76,0.975 PMOS_VTL
M$6 18 2 4 16 PMOS_VTL L=0.05U W=0.42U AS=0.018075P AD=0.0294P PS=0.565U
+ PD=0.56U
* device instance $7 r0 *1 0.95,0.975 PMOS_VTL
M$7 16 14 18 16 PMOS_VTL L=0.05U W=0.42U AS=0.0294P AD=0.025725P PS=0.56U
+ PD=0.56U
* device instance $8 r0 *1 1.14,1.0275 PMOS_VTL
M$8 3 4 16 16 PMOS_VTL L=0.05U W=0.315U AS=0.025725P AD=0.0567P PS=0.56U
+ PD=0.99U
* device instance $9 r0 *1 1.555,1.0275 PMOS_VTL
M$9 16 15 5 16 PMOS_VTL L=0.05U W=0.315U AS=0.033075P AD=0.02205P PS=0.84U
+ PD=0.455U
* device instance $10 r0 *1 1.745,1.0275 PMOS_VTL
M$10 19 4 16 16 PMOS_VTL L=0.05U W=0.315U AS=0.02205P AD=0.02205P PS=0.455U
+ PD=0.455U
* device instance $11 r0 *1 1.935,1.0275 PMOS_VTL
M$11 6 5 19 16 PMOS_VTL L=0.05U W=0.315U AS=0.02205P AD=0.014175P PS=0.455U
+ PD=0.455U
* device instance $12 r0 *1 2.125,1.14 PMOS_VTL
M$12 20 2 6 16 PMOS_VTL L=0.05U W=0.09U AS=0.014175P AD=0.006525P PS=0.455U
+ PD=0.235U
* device instance $13 r0 *1 2.32,1.14 PMOS_VTL
M$13 20 7 16 16 PMOS_VTL L=0.05U W=0.09U AS=0.014175P AD=0.006525P PS=0.455U
+ PD=0.235U
* device instance $14 r0 *1 2.51,1.0275 PMOS_VTL
M$14 7 6 16 16 PMOS_VTL L=0.05U W=0.315U AS=0.014175P AD=0.033075P PS=0.455U
+ PD=0.84U
* device instance $15 r0 *1 2.85,0.2975 NMOS_VTL
M$15 1 6 8 1 NMOS_VTL L=0.05U W=0.415U AS=0.043575P AD=0.02905P PS=1.04U
+ PD=0.555U
* device instance $16 r0 *1 3.04,0.2975 NMOS_VTL
M$16 9 7 1 1 NMOS_VTL L=0.05U W=0.415U AS=0.02905P AD=0.043575P PS=0.555U
+ PD=1.04U
* device instance $17 r0 *1 2.125,0.345 NMOS_VTL
M$17 12 5 6 1 NMOS_VTL L=0.05U W=0.09U AS=0.0105P AD=0.006525P PS=0.35U
+ PD=0.235U
* device instance $18 r0 *1 2.32,0.345 NMOS_VTL
M$18 12 7 1 1 NMOS_VTL L=0.05U W=0.09U AS=0.0105P AD=0.006525P PS=0.35U
+ PD=0.235U
* device instance $19 r0 *1 1.555,0.36 NMOS_VTL
M$19 1 15 5 1 NMOS_VTL L=0.05U W=0.21U AS=0.02205P AD=0.0147P PS=0.63U PD=0.35U
* device instance $20 r0 *1 1.745,0.36 NMOS_VTL
M$20 13 4 1 1 NMOS_VTL L=0.05U W=0.21U AS=0.0147P AD=0.0147P PS=0.35U PD=0.35U
* device instance $21 r0 *1 1.935,0.36 NMOS_VTL
M$21 6 2 13 1 NMOS_VTL L=0.05U W=0.21U AS=0.0147P AD=0.0105P PS=0.35U PD=0.35U
* device instance $22 r0 *1 2.51,0.36 NMOS_VTL
M$22 7 6 1 1 NMOS_VTL L=0.05U W=0.21U AS=0.0105P AD=0.02205P PS=0.35U PD=0.63U
* device instance $23 r0 *1 0.185,0.285 NMOS_VTL
M$23 1 5 2 1 NMOS_VTL L=0.05U W=0.21U AS=0.02205P AD=0.0105P PS=0.63U PD=0.35U
* device instance $24 r0 *1 0.375,0.345 NMOS_VTL
M$24 10 3 1 1 NMOS_VTL L=0.05U W=0.09U AS=0.0105P AD=0.0063P PS=0.35U PD=0.23U
* device instance $25 r0 *1 0.565,0.345 NMOS_VTL
M$25 10 2 4 1 NMOS_VTL L=0.05U W=0.09U AS=0.013P AD=0.0063P PS=0.42U PD=0.23U
* device instance $26 r0 *1 1.14,0.285 NMOS_VTL
M$26 3 4 1 1 NMOS_VTL L=0.05U W=0.21U AS=0.016975P AD=0.02205P PS=0.415U
+ PD=0.63U
* device instance $27 r0 *1 0.76,0.3175 NMOS_VTL
M$27 11 5 4 1 NMOS_VTL L=0.05U W=0.275U AS=0.013P AD=0.01925P PS=0.42U PD=0.415U
* device instance $28 r0 *1 0.95,0.3175 NMOS_VTL
M$28 1 14 11 1 NMOS_VTL L=0.05U W=0.275U AS=0.01925P AD=0.016975P PS=0.415U
+ PD=0.415U
.ENDS DFF_X1

* cell BUF_X1
* pin A
* pin VSS
* pin NWELL,VDD
* pin Z
.SUBCKT BUF_X1 1 3 4 5
* net 1 A
* net 3 VSS
* net 4 NWELL,VDD
* net 5 Z
* device instance $1 r0 *1 0.17,1.1525 PMOS_VTL
M$1 2 1 4 4 PMOS_VTL L=0.05U W=0.315U AS=0.033075P AD=0.033075P PS=0.77U
+ PD=0.84U
* device instance $2 r0 *1 0.36,0.995 PMOS_VTL
M$2 5 2 4 4 PMOS_VTL L=0.05U W=0.63U AS=0.033075P AD=0.06615P PS=0.77U PD=1.47U
* device instance $3 r0 *1 0.17,0.195 NMOS_VTL
M$3 3 1 2 3 NMOS_VTL L=0.05U W=0.21U AS=0.02205P AD=0.021875P PS=0.63U PD=0.555U
* device instance $4 r0 *1 0.36,0.2975 NMOS_VTL
M$4 5 2 3 3 NMOS_VTL L=0.05U W=0.415U AS=0.021875P AD=0.043575P PS=0.555U
+ PD=1.04U
.ENDS BUF_X1

* cell DFFR_X1
* pin VSS
* pin CK
* pin QN
* pin Q
* pin D
* pin RN
* pin NWELL,VDD
.SUBCKT DFFR_X1 1 3 8 9 16 18 19
* net 1 VSS
* net 3 CK
* net 8 QN
* net 9 Q
* net 16 D
* net 18 RN
* net 19 NWELL,VDD
* device instance $1 r0 *1 3.41,0.995 PMOS_VTL
M$1 19 6 8 19 PMOS_VTL L=0.05U W=0.63U AS=0.06615P AD=0.0441P PS=1.47U PD=0.77U
* device instance $2 r0 *1 3.6,0.995 PMOS_VTL
M$2 9 7 19 19 PMOS_VTL L=0.05U W=0.63U AS=0.0441P AD=0.06615P PS=0.77U PD=1.47U
* device instance $3 r0 *1 2.455,1.04 PMOS_VTL
M$3 21 4 6 19 PMOS_VTL L=0.05U W=0.09U AS=0.014175P AD=0.0063P PS=0.455U
+ PD=0.23U
* device instance $4 r0 *1 2.645,1.04 PMOS_VTL
M$4 19 7 21 19 PMOS_VTL L=0.05U W=0.09U AS=0.0063P AD=0.014175P PS=0.23U
+ PD=0.455U
* device instance $5 r0 *1 1.815,1.0125 PMOS_VTL
M$5 19 5 17 19 PMOS_VTL L=0.05U W=0.315U AS=0.03465P AD=0.033075P PS=0.85U
+ PD=0.525U
* device instance $6 r0 *1 2.075,1.0125 PMOS_VTL
M$6 23 5 19 19 PMOS_VTL L=0.05U W=0.315U AS=0.033075P AD=0.02205P PS=0.525U
+ PD=0.455U
* device instance $7 r0 *1 2.265,1.0125 PMOS_VTL
M$7 6 2 23 19 PMOS_VTL L=0.05U W=0.315U AS=0.02205P AD=0.014175P PS=0.455U
+ PD=0.455U
* device instance $8 r0 *1 2.835,1.1525 PMOS_VTL
M$8 7 18 19 19 PMOS_VTL L=0.05U W=0.315U AS=0.014175P AD=0.02205P PS=0.455U
+ PD=0.455U
* device instance $9 r0 *1 3.025,1.1525 PMOS_VTL
M$9 19 6 7 19 PMOS_VTL L=0.05U W=0.315U AS=0.02205P AD=0.033075P PS=0.455U
+ PD=0.84U
* device instance $10 r0 *1 1.08,1.065 PMOS_VTL
M$10 20 2 5 19 PMOS_VTL L=0.05U W=0.09U AS=0.01785P AD=0.0063P PS=0.56U PD=0.23U
* device instance $11 r0 *1 1.27,1.065 PMOS_VTL
M$11 19 17 20 19 PMOS_VTL L=0.05U W=0.09U AS=0.0063P AD=0.0063P PS=0.23U
+ PD=0.23U
* device instance $12 r0 *1 1.46,1.065 PMOS_VTL
M$12 20 18 19 19 PMOS_VTL L=0.05U W=0.09U AS=0.0063P AD=0.01035P PS=0.23U
+ PD=0.41U
* device instance $13 r0 *1 0.7,1.05 PMOS_VTL
M$13 22 16 19 19 PMOS_VTL L=0.05U W=0.42U AS=0.0441P AD=0.0294P PS=1.05U
+ PD=0.56U
* device instance $14 r0 *1 0.89,1.05 PMOS_VTL
M$14 5 4 22 19 PMOS_VTL L=0.05U W=0.42U AS=0.0294P AD=0.01785P PS=0.56U PD=0.56U
* device instance $15 r0 *1 0.17,1.1525 PMOS_VTL
M$15 19 3 2 19 PMOS_VTL L=0.05U W=0.315U AS=0.033075P AD=0.02205P PS=0.84U
+ PD=0.455U
* device instance $16 r0 *1 0.36,1.1525 PMOS_VTL
M$16 4 2 19 19 PMOS_VTL L=0.05U W=0.315U AS=0.02205P AD=0.033075P PS=0.455U
+ PD=0.84U
* device instance $17 r0 *1 1.08,0.35 NMOS_VTL
M$17 12 4 5 1 NMOS_VTL L=0.05U W=0.09U AS=0.012775P AD=0.0063P PS=0.415U
+ PD=0.23U
* device instance $18 r0 *1 1.27,0.35 NMOS_VTL
M$18 11 17 12 1 NMOS_VTL L=0.05U W=0.09U AS=0.0063P AD=0.0063P PS=0.23U PD=0.23U
* device instance $19 r0 *1 1.46,0.35 NMOS_VTL
M$19 1 18 11 1 NMOS_VTL L=0.05U W=0.09U AS=0.0063P AD=0.00945P PS=0.23U PD=0.39U
* device instance $20 r0 *1 0.7,0.3525 NMOS_VTL
M$20 10 16 1 1 NMOS_VTL L=0.05U W=0.275U AS=0.028875P AD=0.01925P PS=0.76U
+ PD=0.415U
* device instance $21 r0 *1 0.89,0.3525 NMOS_VTL
M$21 5 2 10 1 NMOS_VTL L=0.05U W=0.275U AS=0.01925P AD=0.012775P PS=0.415U
+ PD=0.415U
* device instance $22 r0 *1 0.17,0.245 NMOS_VTL
M$22 1 3 2 1 NMOS_VTL L=0.05U W=0.21U AS=0.02205P AD=0.0147P PS=0.63U PD=0.35U
* device instance $23 r0 *1 0.36,0.245 NMOS_VTL
M$23 4 2 1 1 NMOS_VTL L=0.05U W=0.21U AS=0.0147P AD=0.02205P PS=0.35U PD=0.63U
* device instance $24 r0 *1 2.455,0.26 NMOS_VTL
M$24 15 2 6 1 NMOS_VTL L=0.05U W=0.09U AS=0.0105P AD=0.0063P PS=0.35U PD=0.23U
* device instance $25 r0 *1 2.645,0.26 NMOS_VTL
M$25 1 7 15 1 NMOS_VTL L=0.05U W=0.09U AS=0.0063P AD=0.0105P PS=0.23U PD=0.35U
* device instance $26 r0 *1 1.815,0.32 NMOS_VTL
M$26 1 5 17 1 NMOS_VTL L=0.05U W=0.21U AS=0.02205P AD=0.02205P PS=0.63U PD=0.42U
* device instance $27 r0 *1 2.075,0.32 NMOS_VTL
M$27 14 5 1 1 NMOS_VTL L=0.05U W=0.21U AS=0.02205P AD=0.0147P PS=0.42U PD=0.35U
* device instance $28 r0 *1 2.265,0.32 NMOS_VTL
M$28 6 4 14 1 NMOS_VTL L=0.05U W=0.21U AS=0.0147P AD=0.0105P PS=0.35U PD=0.35U
* device instance $29 r0 *1 2.835,0.32 NMOS_VTL
M$29 13 18 1 1 NMOS_VTL L=0.05U W=0.21U AS=0.0105P AD=0.0147P PS=0.35U PD=0.35U
* device instance $30 r0 *1 3.025,0.32 NMOS_VTL
M$30 7 6 13 1 NMOS_VTL L=0.05U W=0.21U AS=0.0147P AD=0.02205P PS=0.35U PD=0.63U
* device instance $31 r0 *1 3.41,0.2975 NMOS_VTL
M$31 1 6 8 1 NMOS_VTL L=0.05U W=0.415U AS=0.043575P AD=0.02905P PS=1.04U
+ PD=0.555U
* device instance $32 r0 *1 3.6,0.2975 NMOS_VTL
M$32 9 7 1 1 NMOS_VTL L=0.05U W=0.415U AS=0.02905P AD=0.043575P PS=0.555U
+ PD=1.04U
.ENDS DFFR_X1

* cell CLKBUF_X3
* pin A
* pin VSS
* pin NWELL,VDD
* pin Z
.SUBCKT CLKBUF_X3 1 3 4 5
* net 1 A
* net 3 VSS
* net 4 NWELL,VDD
* net 5 Z
* device instance $1 r0 *1 0.17,0.995 PMOS_VTL
M$1 4 1 2 4 PMOS_VTL L=0.05U W=0.63U AS=0.06615P AD=0.0441P PS=1.47U PD=0.77U
* device instance $2 r0 *1 0.36,0.995 PMOS_VTL
M$2 5 2 4 4 PMOS_VTL L=0.05U W=1.89U AS=0.1323P AD=0.15435P PS=2.31U PD=3.01U
* device instance $5 r0 *1 0.17,0.1875 NMOS_VTL
M$5 3 1 2 3 NMOS_VTL L=0.05U W=0.195U AS=0.020475P AD=0.01365P PS=0.6U PD=0.335U
* device instance $6 r0 *1 0.36,0.1875 NMOS_VTL
M$6 5 2 3 3 NMOS_VTL L=0.05U W=0.585U AS=0.04095P AD=0.047775P PS=1.005U
+ PD=1.27U
.ENDS CLKBUF_X3

* cell HA_X1
* pin A
* pin B
* pin S
* pin NWELL,VDD
* pin VSS
* pin CO
.SUBCKT HA_X1 1 2 4 5 6 9
* net 1 A
* net 2 B
* net 4 S
* net 5 NWELL,VDD
* net 6 VSS
* net 9 CO
* device instance $1 r0 *1 0.785,1.0275 PMOS_VTL
M$1 10 2 5 5 PMOS_VTL L=0.05U W=0.315U AS=0.0338625P AD=0.02205P PS=0.775U
+ PD=0.455U
* device instance $2 r0 *1 0.975,1.0275 PMOS_VTL
M$2 7 1 10 5 PMOS_VTL L=0.05U W=0.315U AS=0.02205P AD=0.033075P PS=0.455U
+ PD=0.84U
* device instance $3 r0 *1 0.21,0.995 PMOS_VTL
M$3 4 2 3 5 PMOS_VTL L=0.05U W=0.63U AS=0.06615P AD=0.0441P PS=1.47U PD=0.77U
* device instance $4 r0 *1 0.4,0.995 PMOS_VTL
M$4 3 1 4 5 PMOS_VTL L=0.05U W=0.63U AS=0.0441P AD=0.0441P PS=0.77U PD=0.77U
* device instance $5 r0 *1 0.59,0.995 PMOS_VTL
M$5 5 7 3 5 PMOS_VTL L=0.05U W=0.63U AS=0.0441P AD=0.0338625P PS=0.77U PD=0.775U
* device instance $6 r0 *1 1.345,1.0275 PMOS_VTL
M$6 8 1 5 5 PMOS_VTL L=0.05U W=0.315U AS=0.033075P AD=0.02205P PS=0.84U
+ PD=0.455U
* device instance $7 r0 *1 1.535,1.0275 PMOS_VTL
M$7 8 2 5 5 PMOS_VTL L=0.05U W=0.315U AS=0.033075P AD=0.02205P PS=0.77U
+ PD=0.455U
* device instance $8 r0 *1 1.725,0.995 PMOS_VTL
M$8 9 8 5 5 PMOS_VTL L=0.05U W=0.63U AS=0.033075P AD=0.06615P PS=0.77U PD=1.47U
* device instance $9 r0 *1 1.345,0.195 NMOS_VTL
M$9 12 1 8 6 NMOS_VTL L=0.05U W=0.21U AS=0.02205P AD=0.0147P PS=0.63U PD=0.35U
* device instance $10 r0 *1 1.535,0.195 NMOS_VTL
M$10 6 2 12 6 NMOS_VTL L=0.05U W=0.21U AS=0.0147P AD=0.021875P PS=0.35U
+ PD=0.555U
* device instance $11 r0 *1 1.725,0.2975 NMOS_VTL
M$11 9 8 6 6 NMOS_VTL L=0.05U W=0.415U AS=0.021875P AD=0.043575P PS=0.555U
+ PD=1.04U
* device instance $12 r0 *1 0.785,0.195 NMOS_VTL
M$12 7 2 6 6 NMOS_VTL L=0.05U W=0.21U AS=0.0224P AD=0.0147P PS=0.56U PD=0.35U
* device instance $13 r0 *1 0.975,0.195 NMOS_VTL
M$13 6 1 7 6 NMOS_VTL L=0.05U W=0.21U AS=0.0147P AD=0.02205P PS=0.35U PD=0.63U
* device instance $14 r0 *1 0.21,0.2975 NMOS_VTL
M$14 11 2 6 6 NMOS_VTL L=0.05U W=0.415U AS=0.043575P AD=0.02905P PS=1.04U
+ PD=0.555U
* device instance $15 r0 *1 0.4,0.2975 NMOS_VTL
M$15 4 1 11 6 NMOS_VTL L=0.05U W=0.415U AS=0.02905P AD=0.02905P PS=0.555U
+ PD=0.555U
* device instance $16 r0 *1 0.59,0.2975 NMOS_VTL
M$16 6 7 4 6 NMOS_VTL L=0.05U W=0.415U AS=0.02905P AD=0.0224P PS=0.555U PD=0.56U
.ENDS HA_X1

* cell OAI21_X2
* pin A
* pin B2
* pin B1
* pin NWELL,VDD
* pin VSS
* pin ZN
.SUBCKT OAI21_X2 1 2 3 5 6 7
* net 1 A
* net 2 B2
* net 3 B1
* net 5 NWELL,VDD
* net 6 VSS
* net 7 ZN
* device instance $1 r0 *1 0.17,0.995 PMOS_VTL
M$1 7 1 5 5 PMOS_VTL L=0.05U W=1.26U AS=0.11025P AD=0.0882P PS=2.24U PD=1.54U
* device instance $3 r0 *1 0.55,0.995 PMOS_VTL
M$3 8 2 5 5 PMOS_VTL L=0.05U W=0.63U AS=0.0441P AD=0.0441P PS=0.77U PD=0.77U
* device instance $4 r0 *1 0.74,0.995 PMOS_VTL
M$4 7 3 8 5 PMOS_VTL L=0.05U W=0.63U AS=0.0441P AD=0.0441P PS=0.77U PD=0.77U
* device instance $5 r0 *1 0.93,0.995 PMOS_VTL
M$5 9 3 7 5 PMOS_VTL L=0.05U W=0.63U AS=0.0441P AD=0.0441P PS=0.77U PD=0.77U
* device instance $6 r0 *1 1.12,0.995 PMOS_VTL
M$6 5 2 9 5 PMOS_VTL L=0.05U W=0.63U AS=0.0441P AD=0.06615P PS=0.77U PD=1.47U
* device instance $7 r0 *1 0.17,0.2975 NMOS_VTL
M$7 6 1 4 6 NMOS_VTL L=0.05U W=0.83U AS=0.072625P AD=0.0581P PS=1.595U PD=1.11U
* device instance $9 r0 *1 0.55,0.2975 NMOS_VTL
M$9 7 2 4 6 NMOS_VTL L=0.05U W=0.83U AS=0.0581P AD=0.072625P PS=1.11U PD=1.595U
* device instance $10 r0 *1 0.74,0.2975 NMOS_VTL
M$10 4 3 7 6 NMOS_VTL L=0.05U W=0.83U AS=0.0581P AD=0.0581P PS=1.11U PD=1.11U
.ENDS OAI21_X2

* cell NAND3_X1
* pin A3
* pin A2
* pin A1
* pin VSS
* pin NWELL,VDD
* pin ZN
.SUBCKT NAND3_X1 1 2 3 4 5 6
* net 1 A3
* net 2 A2
* net 3 A1
* net 4 VSS
* net 5 NWELL,VDD
* net 6 ZN
* device instance $1 r0 *1 0.17,0.995 PMOS_VTL
M$1 6 1 5 5 PMOS_VTL L=0.05U W=0.63U AS=0.06615P AD=0.0441P PS=1.47U PD=0.77U
* device instance $2 r0 *1 0.36,0.995 PMOS_VTL
M$2 5 2 6 5 PMOS_VTL L=0.05U W=0.63U AS=0.0441P AD=0.0441P PS=0.77U PD=0.77U
* device instance $3 r0 *1 0.55,0.995 PMOS_VTL
M$3 6 3 5 5 PMOS_VTL L=0.05U W=0.63U AS=0.0441P AD=0.06615P PS=0.77U PD=1.47U
* device instance $4 r0 *1 0.17,0.2975 NMOS_VTL
M$4 8 1 4 4 NMOS_VTL L=0.05U W=0.415U AS=0.043575P AD=0.02905P PS=1.04U
+ PD=0.555U
* device instance $5 r0 *1 0.36,0.2975 NMOS_VTL
M$5 7 2 8 4 NMOS_VTL L=0.05U W=0.415U AS=0.02905P AD=0.02905P PS=0.555U
+ PD=0.555U
* device instance $6 r0 *1 0.55,0.2975 NMOS_VTL
M$6 6 3 7 4 NMOS_VTL L=0.05U W=0.415U AS=0.02905P AD=0.043575P PS=0.555U
+ PD=1.04U
.ENDS NAND3_X1

* cell OAI21_X1
* pin B2
* pin B1
* pin A
* pin NWELL,VDD
* pin ZN
* pin VSS
.SUBCKT OAI21_X1 1 2 3 5 6 7
* net 1 B2
* net 2 B1
* net 3 A
* net 5 NWELL,VDD
* net 6 ZN
* net 7 VSS
* device instance $1 r0 *1 0.195,0.995 PMOS_VTL
M$1 8 1 5 5 PMOS_VTL L=0.05U W=0.63U AS=0.06615P AD=0.0441P PS=1.47U PD=0.77U
* device instance $2 r0 *1 0.385,0.995 PMOS_VTL
M$2 6 2 8 5 PMOS_VTL L=0.05U W=0.63U AS=0.0441P AD=0.0441P PS=0.77U PD=0.77U
* device instance $3 r0 *1 0.575,0.995 PMOS_VTL
M$3 5 3 6 5 PMOS_VTL L=0.05U W=0.63U AS=0.0441P AD=0.06615P PS=0.77U PD=1.47U
* device instance $4 r0 *1 0.195,0.2975 NMOS_VTL
M$4 6 1 4 7 NMOS_VTL L=0.05U W=0.415U AS=0.043575P AD=0.02905P PS=1.04U
+ PD=0.555U
* device instance $5 r0 *1 0.385,0.2975 NMOS_VTL
M$5 4 2 6 7 NMOS_VTL L=0.05U W=0.415U AS=0.02905P AD=0.02905P PS=0.555U
+ PD=0.555U
* device instance $6 r0 *1 0.575,0.2975 NMOS_VTL
M$6 7 3 4 7 NMOS_VTL L=0.05U W=0.415U AS=0.02905P AD=0.043575P PS=0.555U
+ PD=1.04U
.ENDS OAI21_X1

* cell NAND2_X1
* pin A2
* pin A1
* pin VSS
* pin NWELL,VDD
* pin ZN
.SUBCKT NAND2_X1 1 2 3 4 5
* net 1 A2
* net 2 A1
* net 3 VSS
* net 4 NWELL,VDD
* net 5 ZN
* device instance $1 r0 *1 0.185,0.995 PMOS_VTL
M$1 5 1 4 4 PMOS_VTL L=0.05U W=0.63U AS=0.06615P AD=0.0441P PS=1.47U PD=0.77U
* device instance $2 r0 *1 0.375,0.995 PMOS_VTL
M$2 4 2 5 4 PMOS_VTL L=0.05U W=0.63U AS=0.0441P AD=0.06615P PS=0.77U PD=1.47U
* device instance $3 r0 *1 0.185,0.2975 NMOS_VTL
M$3 6 1 3 3 NMOS_VTL L=0.05U W=0.415U AS=0.043575P AD=0.02905P PS=1.04U
+ PD=0.555U
* device instance $4 r0 *1 0.375,0.2975 NMOS_VTL
M$4 5 2 6 3 NMOS_VTL L=0.05U W=0.415U AS=0.02905P AD=0.043575P PS=0.555U
+ PD=1.04U
.ENDS NAND2_X1

* cell MUX2_X1
* pin A
* pin S
* pin B
* pin VSS
* pin NWELL,VDD
* pin Z
.SUBCKT MUX2_X1 1 2 3 5 6 8
* net 1 A
* net 2 S
* net 3 B
* net 5 VSS
* net 6 NWELL,VDD
* net 8 Z
* device instance $1 r0 *1 0.17,1.1525 PMOS_VTL
M$1 6 2 4 6 PMOS_VTL L=0.05U W=0.315U AS=0.033075P AD=0.02205P PS=0.84U
+ PD=0.455U
* device instance $2 r0 *1 0.36,1.1525 PMOS_VTL
M$2 9 1 6 6 PMOS_VTL L=0.05U W=0.315U AS=0.02205P AD=0.02205P PS=0.455U
+ PD=0.455U
* device instance $3 r0 *1 0.55,1.1525 PMOS_VTL
M$3 7 2 9 6 PMOS_VTL L=0.05U W=0.315U AS=0.02205P AD=0.02205P PS=0.455U
+ PD=0.455U
* device instance $4 r0 *1 0.74,1.1525 PMOS_VTL
M$4 10 4 7 6 PMOS_VTL L=0.05U W=0.315U AS=0.02205P AD=0.02205P PS=0.455U
+ PD=0.455U
* device instance $5 r0 *1 0.93,1.1525 PMOS_VTL
M$5 10 3 6 6 PMOS_VTL L=0.05U W=0.315U AS=0.033075P AD=0.02205P PS=0.77U
+ PD=0.455U
* device instance $6 r0 *1 1.12,0.995 PMOS_VTL
M$6 8 7 6 6 PMOS_VTL L=0.05U W=0.63U AS=0.033075P AD=0.06615P PS=0.77U PD=1.47U
* device instance $7 r0 *1 0.17,0.195 NMOS_VTL
M$7 5 2 4 5 NMOS_VTL L=0.05U W=0.21U AS=0.02205P AD=0.0147P PS=0.63U PD=0.35U
* device instance $8 r0 *1 0.36,0.195 NMOS_VTL
M$8 12 1 5 5 NMOS_VTL L=0.05U W=0.21U AS=0.0147P AD=0.0147P PS=0.35U PD=0.35U
* device instance $9 r0 *1 0.55,0.195 NMOS_VTL
M$9 7 4 12 5 NMOS_VTL L=0.05U W=0.21U AS=0.0147P AD=0.0147P PS=0.35U PD=0.35U
* device instance $10 r0 *1 0.74,0.195 NMOS_VTL
M$10 11 2 7 5 NMOS_VTL L=0.05U W=0.21U AS=0.0147P AD=0.0147P PS=0.35U PD=0.35U
* device instance $11 r0 *1 0.93,0.195 NMOS_VTL
M$11 5 3 11 5 NMOS_VTL L=0.05U W=0.21U AS=0.0147P AD=0.021875P PS=0.35U
+ PD=0.555U
* device instance $12 r0 *1 1.12,0.2975 NMOS_VTL
M$12 8 7 5 5 NMOS_VTL L=0.05U W=0.415U AS=0.021875P AD=0.043575P PS=0.555U
+ PD=1.04U
.ENDS MUX2_X1

* cell INV_X1
* pin A
* pin VSS
* pin NWELL,VDD
* pin ZN
.SUBCKT INV_X1 1 2 3 4
* net 1 A
* net 2 VSS
* net 3 NWELL,VDD
* net 4 ZN
* device instance $1 r0 *1 0.17,0.995 PMOS_VTL
M$1 4 1 3 3 PMOS_VTL L=0.05U W=0.63U AS=0.06615P AD=0.06615P PS=1.47U PD=1.47U
* device instance $2 r0 *1 0.17,0.2975 NMOS_VTL
M$2 4 1 2 2 NMOS_VTL L=0.05U W=0.415U AS=0.043575P AD=0.043575P PS=1.04U
+ PD=1.04U
.ENDS INV_X1
