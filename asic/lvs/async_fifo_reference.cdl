* CDL Netlist generated by OpenROAD

*.BUSDELIMITER [

.SUBCKT async_fifo empty full read_clk read_data[0] read_data[1]
+ read_data[2] read_data[3] read_data[4] read_data[5] read_data[6]
+ read_data[7] read_en rst_n write_clk write_data[0] write_data[1]
+ write_data[2] write_data[3] write_data[4] write_data[5] write_data[6]
+ write_data[7] write_en VSS VDD
X_433_ memory_inst.write_addr\[1\] _004_ _089_ VDD VSS XNOR2_X1
X_434_ _089_ wr_gray_next.binary\[1\] VDD VSS INV_X1
X_435_ _001_ mem_write_en VDD VSS INV_X4
Xclkbuf_3_0__f_write_clk clknet_0_write_clk clknet_3_0__leaf_write_clk
+ VDD VSS CLKBUF_X3
X_437_ memory_inst.mem\[7\]\[4\] net7 _094_ _069_ VDD VSS
+ MUX2_X1
X_438_ _104_ net9 _161_ VDD VSS NAND2_X1
X_439_ memory_inst.mem\[1\]\[6\] _162_ VDD VSS INV_X1
X_440_ _161_ _162_ _104_ _068_ VDD VSS OAI21_X1
X_441_ _152_ status_inst.synced_wr_ptr_gray\[2\] _163_ VDD
+ VSS NAND2_X1
X_442_ status_inst.synced_wr_ptr_gray\[2\] _164_ VDD VSS INV_X1
X_443_ _149_ _151_ _164_ _165_ VDD VSS NAND3_X1
X_444_ _163_ _165_ _166_ VDD VSS NAND2_X1
X_445_ _166_ status_inst.synced_wr_ptr_gray\[3\] _167_ VDD
+ VSS NAND2_X1
X_446_ net1 _000_ _014_ VDD VSS NAND2_X4
X_447_ _163_ _165_ _099_ _168_ VDD VSS NAND3_X1
X_448_ _167_ _168_ _169_ VDD VSS NAND2_X1
X_449_ _169_ _170_ VDD VSS INV_X1
X_450_ memory_inst.read_addr\[1\] status_inst.synced_wr_ptr_gray\[0\]
+ _171_ VDD VSS XNOR2_X1
X_451_ _171_ _015_ _172_ VDD VSS XNOR2_X1
X_452_ status_inst.synced_wr_ptr_gray\[3\] _173_ VDD VSS INV_X1
X_453_ _172_ _173_ rd_gray_next.binary\[3\] _174_ VDD VSS
+ OAI21_X1
X_454_ _174_ _175_ VDD VSS INV_X1
X_455_ _012_ rd_gray_current.gray\[0\] VDD VSS INV_X1
X_456_ _095_ rd_gray_current.gray\[0\] _176_ VDD VSS NAND2_X1
X_457_ _014_ _095_ VDD VSS INV_X4
X_458_ _014_ memory_inst.read_addr\[1\] _177_ VDD VSS NAND2_X1
X_459_ _176_ _177_ rd_gray_next.binary\[1\] VDD VSS NAND2_X1
X_460_ status_inst.synced_wr_ptr_gray\[1\] _178_ VDD VSS INV_X1
X_461_ rd_gray_next.binary\[1\] _178_ _179_ VDD VSS NAND2_X1
X_462_ _176_ status_inst.synced_wr_ptr_gray\[1\] _177_ _180_
+ VDD VSS NAND3_X1
X_463_ _179_ _180_ _181_ VDD VSS NAND2_X1
X_464_ _181_ rd_gray_next.binary\[2\] _182_ VDD VSS NAND2_X1
X_465_ _179_ _152_ _180_ _183_ VDD VSS NAND3_X1
X_466_ _182_ _183_ _184_ VDD VSS NAND2_X1
X_467_ _175_ _184_ _185_ VDD VSS NAND2_X1
Xplace24 memory_inst.read_addr\[0\] net24 VDD VSS BUF_X1
X_469_ _170_ _185_ empty_next VDD VSS NOR2_X2
X_470_ _104_ net8 _186_ VDD VSS NAND2_X1
X_471_ memory_inst.mem\[1\]\[5\] _187_ VDD VSS INV_X1
X_472_ _186_ _187_ _104_ _067_ VDD VSS OAI21_X1
X_473_ memory_inst.read_addr\[0\] memory_inst.mem\[0\]\[0\]
+ _188_ VDD VSS OR2_X1
X_474_ memory_inst.mem\[1\]\[0\] _189_ VDD VSS INV_X1
X_475_ _189_ memory_inst.read_addr\[0\] _190_ VDD VSS NAND2_X1
X_476_ _188_ _190_ _125_ _191_ VDD VSS NAND3_X1
X_477_ _013_ memory_inst.mem\[3\]\[0\] _192_ VDD VSS NAND2_X1
Xclkbuf_0_write_clk write_clk clknet_0_write_clk VDD VSS CLKBUF_X3
Xplace25 net2 net25 VDD VSS BUF_X1
X_480_ memory_inst.mem\[2\]\[0\] _011_ _194_ VDD VSS NAND2_X1
X_481_ _191_ _133_ _192_ _194_ _195_ VDD VSS NAND4_X1
X_482_ _128_ memory_inst.mem\[5\]\[0\] _196_ VDD VSS OR2_X1
X_483_ memory_inst.read_addr\[0\] memory_inst.mem\[4\]\[0\]
+ _197_ VDD VSS OR2_X1
X_484_ _196_ _197_ _125_ _198_ VDD VSS NAND3_X1
X_485_ memory_inst.mem\[6\]\[0\] _199_ VDD VSS INV_X1
X_486_ _011_ _200_ VDD VSS INV_X1
X_487_ memory_inst.read_addr\[2\] _199_ _200_ _201_ VDD VSS
+ OAI21_X1
X_488_ _201_ _202_ VDD VSS INV_X1
X_489_ _013_ memory_inst.mem\[7\]\[0\] _203_ VDD VSS NAND2_X1
X_490_ memory_inst.mem\[7\]\[1\] net4 _094_ _088_ VDD VSS
+ MUX2_X1
X_491_ _198_ _202_ _203_ _204_ VDD VSS NAND3_X1
X_492_ _195_ _095_ _204_ _205_ VDD VSS NAND3_X1
X_493_ net14 _206_ VDD VSS INV_X1
X_494_ _205_ _206_ _095_ _066_ VDD VSS OAI21_X1
X_495_ memory_inst.read_addr\[0\] memory_inst.mem\[0\]\[1\]
+ _207_ VDD VSS OR2_X1
X_496_ memory_inst.mem\[1\]\[1\] _208_ VDD VSS INV_X1
X_497_ _208_ memory_inst.read_addr\[0\] _209_ VDD VSS NAND2_X1
X_498_ _207_ _209_ _125_ _210_ VDD VSS NAND3_X1
X_499_ memory_inst.mem\[2\]\[1\] _011_ _211_ VDD VSS NAND2_X1
X_500_ _013_ memory_inst.mem\[3\]\[1\] _212_ VDD VSS NAND2_X1
X_501_ _016_ _010_ _097_ VDD VSS NAND2_X1
X_502_ _210_ _133_ _211_ _212_ _213_ VDD VSS NAND4_X1
X_503_ memory_inst.mem\[4\]\[1\] _214_ VDD VSS INV_X1
X_504_ _128_ _214_ _215_ VDD VSS NAND2_X1
X_505_ memory_inst.mem\[5\]\[1\] _216_ VDD VSS INV_X1
X_506_ _216_ memory_inst.read_addr\[0\] _217_ VDD VSS NAND2_X1
X_507_ _215_ _217_ _125_ _218_ VDD VSS NAND3_X1
X_508_ _013_ memory_inst.mem\[7\]\[1\] _219_ VDD VSS NAND2_X1
X_509_ memory_inst.mem\[6\]\[1\] _011_ _220_ VDD VSS NAND2_X1
X_510_ _218_ memory_inst.read_addr\[2\] _219_ _220_ _221_
+ VDD VSS NAND4_X1
X_511_ _213_ _221_ _095_ _222_ VDD VSS NAND3_X1
X_512_ rd_gray_current.binary\[3\] _098_ VDD VSS INV_X1
X_513_ net15 _223_ VDD VSS INV_X1
X_514_ _222_ _223_ _095_ _065_ VDD VSS OAI21_X1
X_515_ net24 memory_inst.mem\[0\]\[2\] _224_ VDD VSS NOR2_X1
X_516_ _224_ memory_inst.read_addr\[1\] _225_ VDD VSS NOR2_X1
X_517_ _225_ _128_ memory_inst.mem\[1\]\[2\] _226_ VDD VSS
+ OAI21_X1
X_518_ _013_ memory_inst.mem\[3\]\[2\] _227_ VDD VSS NAND2_X1
X_519_ _011_ memory_inst.mem\[2\]\[2\] _228_ VDD VSS NAND2_X1
X_520_ _226_ _133_ _227_ _228_ _229_ VDD VSS NAND4_X1
X_521_ memory_inst.mem\[6\]\[2\] _230_ VDD VSS INV_X1
X_522_ _125_ _128_ _230_ _231_ VDD VSS AOI21_X1
X_523_ _097_ _098_ _099_ VDD VSS XNOR2_X1
X_524_ _231_ _128_ memory_inst.mem\[7\]\[2\] _232_ VDD VSS
+ OAI21_X1
X_525_ memory_inst.mem\[5\]\[2\] _233_ VDD VSS INV_X1
X_526_ memory_inst.read_addr\[1\] _233_ net24 _234_ VDD VSS
+ AOI21_X1
X_527_ _234_ net24 memory_inst.mem\[4\]\[2\] _235_ VDD VSS
+ OAI21_X1
X_528_ _232_ memory_inst.read_addr\[2\] _235_ _236_ VDD VSS
+ NAND3_X1
X_529_ _229_ _236_ _095_ _237_ VDD VSS NAND3_X1
X_530_ _014_ net16 _238_ VDD VSS NAND2_X1
X_531_ _237_ _238_ _064_ VDD VSS NAND2_X1
X_532_ net24 memory_inst.mem\[0\]\[3\] _239_ VDD VSS NOR2_X1
X_533_ _239_ memory_inst.read_addr\[1\] _240_ VDD VSS NOR2_X1
X_534_ _099_ rd_gray_next.binary\[3\] VDD VSS INV_X1
X_535_ _240_ _128_ memory_inst.mem\[1\]\[3\] _241_ VDD VSS
+ OAI21_X1
X_536_ _013_ memory_inst.mem\[3\]\[3\] _242_ VDD VSS NAND2_X1
X_537_ _011_ memory_inst.mem\[2\]\[3\] _243_ VDD VSS NAND2_X1
X_538_ _241_ _133_ _242_ _243_ _244_ VDD VSS NAND4_X1
X_539_ memory_inst.mem\[6\]\[3\] _245_ VDD VSS INV_X1
X_540_ _125_ _128_ _245_ _246_ VDD VSS AOI21_X1
X_541_ _246_ _128_ memory_inst.mem\[7\]\[3\] _247_ VDD VSS
+ OAI21_X1
X_542_ memory_inst.mem\[5\]\[3\] _248_ VDD VSS INV_X1
X_543_ memory_inst.read_addr\[1\] _248_ net24 _249_ VDD VSS
+ AOI21_X1
X_544_ _249_ net24 memory_inst.mem\[4\]\[3\] _250_ VDD VSS
+ OAI21_X1
X_545_ wr_gray_current.binary\[3\] _090_ VDD VSS INV_X1
Xoutput21 net21 read_data[7] VDD VSS BUF_X1
X_547_ _247_ memory_inst.read_addr\[2\] _250_ _251_ VDD VSS
+ NAND3_X1
X_548_ _244_ _251_ _095_ _252_ VDD VSS NAND3_X1
X_549_ _014_ net17 _253_ VDD VSS NAND2_X1
X_550_ _252_ _253_ _063_ VDD VSS NAND2_X1
X_551_ net24 memory_inst.mem\[0\]\[4\] _254_ VDD VSS NOR2_X1
X_552_ _254_ memory_inst.read_addr\[1\] _255_ VDD VSS NOR2_X1
X_553_ _255_ _128_ memory_inst.mem\[1\]\[4\] _256_ VDD VSS
+ OAI21_X1
X_554_ _013_ memory_inst.mem\[3\]\[4\] _257_ VDD VSS NAND2_X1
X_555_ _011_ memory_inst.mem\[2\]\[4\] _258_ VDD VSS NAND2_X1
X_556_ _256_ _133_ _257_ _258_ _259_ VDD VSS NAND4_X1
X_557_ memory_inst.mem\[7\]\[6\] net9 _094_ _087_ VDD VSS
+ MUX2_X1
X_558_ memory_inst.mem\[6\]\[4\] _260_ VDD VSS INV_X1
X_559_ _125_ _128_ _260_ _261_ VDD VSS AOI21_X1
X_560_ _261_ _128_ memory_inst.mem\[7\]\[4\] _262_ VDD VSS
+ OAI21_X1
X_561_ memory_inst.mem\[5\]\[4\] _263_ VDD VSS INV_X1
X_562_ memory_inst.read_addr\[1\] _263_ net24 _264_ VDD VSS
+ AOI21_X1
X_563_ _264_ net24 memory_inst.mem\[4\]\[4\] _265_ VDD VSS
+ OAI21_X1
X_564_ _262_ memory_inst.read_addr\[2\] _265_ _266_ VDD VSS
+ NAND3_X1
X_565_ _259_ _266_ _095_ _267_ VDD VSS NAND3_X1
X_566_ _014_ net18 _268_ VDD VSS NAND2_X1
X_567_ _267_ _268_ _062_ VDD VSS NAND2_X1
Xoutput20 net20 read_data[6] VDD VSS BUF_X1
X_569_ memory_inst.mem\[6\]\[5\] _269_ VDD VSS INV_X1
X_570_ _125_ _269_ _128_ _270_ VDD VSS AOI21_X1
X_571_ _270_ memory_inst.mem\[7\]\[5\] _128_ _271_ VDD VSS
+ OAI21_X1
X_572_ memory_inst.read_addr\[1\] _158_ net24 _272_ VDD VSS
+ AOI21_X1
X_573_ _272_ net24 memory_inst.mem\[4\]\[5\] _273_ VDD VSS
+ OAI21_X1
X_574_ _271_ memory_inst.read_addr\[2\] _273_ _274_ VDD VSS
+ NAND3_X1
X_575_ memory_inst.read_addr\[0\] memory_inst.mem\[0\]\[5\]
+ _275_ VDD VSS OR2_X1
X_576_ _187_ memory_inst.read_addr\[0\] _276_ VDD VSS NAND2_X1
X_577_ _275_ _276_ _125_ _277_ VDD VSS NAND3_X1
X_578_ _013_ memory_inst.mem\[3\]\[5\] _278_ VDD VSS NAND2_X1
Xoutput19 net19 read_data[5] VDD VSS BUF_X1
X_580_ _011_ memory_inst.mem\[2\]\[5\] _279_ VDD VSS NAND2_X1
X_581_ _277_ _133_ _278_ _279_ _280_ VDD VSS NAND4_X1
X_582_ _274_ _280_ _095_ _281_ VDD VSS NAND3_X1
X_583_ _014_ net19 _282_ VDD VSS NAND2_X1
X_584_ _281_ _282_ _061_ VDD VSS NAND2_X1
X_585_ memory_inst.mem\[6\]\[6\] _283_ VDD VSS INV_X1
X_586_ _125_ _128_ _283_ _284_ VDD VSS AOI21_X1
X_587_ _284_ _128_ memory_inst.mem\[7\]\[6\] _285_ VDD VSS
+ OAI21_X1
X_588_ memory_inst.read_addr\[1\] _154_ net24 _286_ VDD VSS
+ AOI21_X1
X_589_ _286_ net24 memory_inst.mem\[4\]\[6\] _287_ VDD VSS
+ OAI21_X1
X_590_ _006_ _003_ _103_ VDD VSS NAND2_X1
X_591_ _285_ memory_inst.read_addr\[2\] _287_ _288_ VDD VSS
+ NAND3_X1
X_592_ memory_inst.read_addr\[0\] memory_inst.mem\[0\]\[6\]
+ _289_ VDD VSS OR2_X1
X_593_ _162_ memory_inst.read_addr\[0\] _290_ VDD VSS NAND2_X1
X_594_ _289_ _290_ _125_ _291_ VDD VSS NAND3_X1
X_595_ _011_ memory_inst.mem\[2\]\[6\] _292_ VDD VSS NAND2_X1
X_596_ _013_ memory_inst.mem\[3\]\[6\] _293_ VDD VSS NAND2_X1
X_597_ _291_ _133_ _292_ _293_ _294_ VDD VSS NAND4_X1
X_598_ _288_ _294_ _095_ _295_ VDD VSS NAND3_X1
X_599_ _014_ net20 _296_ VDD VSS NAND2_X1
X_600_ _295_ _296_ _060_ VDD VSS NAND2_X1
X_601_ net10 memory_inst.mem\[0\]\[7\] _103_ _086_ VDD VSS
+ MUX2_X1
X_602_ _120_ net9 _297_ VDD VSS NOR2_X1
X_603_ _297_ _283_ _120_ _059_ VDD VSS AOI21_X1
X_604_ _120_ net8 _298_ VDD VSS NOR2_X1
X_605_ _298_ _269_ _120_ _058_ VDD VSS AOI21_X1
X_606_ _120_ net7 _299_ VDD VSS NOR2_X1
X_607_ _299_ _260_ _120_ _057_ VDD VSS AOI21_X1
X_608_ _120_ net6 _300_ VDD VSS NOR2_X1
X_609_ _300_ _245_ _120_ _056_ VDD VSS AOI21_X1
X_610_ _120_ net5 _301_ VDD VSS NOR2_X1
X_611_ _301_ _230_ _120_ _055_ VDD VSS AOI21_X1
X_612_ mem_write_en _006_ memory_inst.write_addr\[0\] _104_
+ VDD VSS AND3_X2
X_613_ net4 memory_inst.mem\[6\]\[1\] _120_ _054_ VDD VSS
+ MUX2_X1
X_614_ _120_ net3 _302_ VDD VSS NOR2_X1
X_615_ _302_ _199_ _120_ _053_ VDD VSS AOI21_X1
X_616_ memory_inst.mem\[1\]\[4\] net7 _104_ _052_ VDD VSS
+ MUX2_X1
X_617_ memory_inst.mem\[1\]\[3\] net6 _104_ _051_ VDD VSS
+ MUX2_X1
X_618_ memory_inst.mem\[1\]\[2\] net5 _104_ _050_ VDD VSS
+ MUX2_X1
X_619_ _104_ net4 _303_ VDD VSS NAND2_X1
X_620_ _303_ _208_ _104_ _049_ VDD VSS OAI21_X1
X_621_ _104_ net3 _304_ VDD VSS NAND2_X1
X_622_ _304_ _189_ _104_ _048_ VDD VSS OAI21_X1
Xoutput18 net18 read_data[4] VDD VSS BUF_X1
X_624_ net9 memory_inst.mem\[0\]\[6\] _103_ _047_ VDD VSS
+ MUX2_X1
X_625_ net8 memory_inst.mem\[0\]\[5\] _103_ _046_ VDD VSS
+ MUX2_X1
X_626_ net7 memory_inst.mem\[0\]\[4\] _103_ _045_ VDD VSS
+ MUX2_X1
X_627_ net6 memory_inst.mem\[0\]\[3\] _103_ _044_ VDD VSS
+ MUX2_X1
X_628_ net5 memory_inst.mem\[0\]\[2\] _103_ _043_ VDD VSS
+ MUX2_X1
X_629_ net4 memory_inst.mem\[0\]\[1\] _103_ _042_ VDD VSS
+ MUX2_X1
X_630_ net3 memory_inst.mem\[0\]\[0\] _103_ _041_ VDD VSS
+ MUX2_X1
X_631_ _116_ net7 _305_ VDD VSS NAND2_X1
X_632_ _305_ _263_ _116_ _040_ VDD VSS OAI21_X1
X_633_ _116_ net6 _306_ VDD VSS NAND2_X1
X_634_ _104_ net10 _106_ VDD VSS NAND2_X1
X_635_ _306_ _248_ _116_ _039_ VDD VSS OAI21_X1
X_636_ _116_ net5 _307_ VDD VSS NAND2_X1
X_637_ _307_ _233_ _116_ _038_ VDD VSS OAI21_X1
X_638_ _116_ net4 _308_ VDD VSS NAND2_X1
X_639_ _308_ _216_ _116_ _037_ VDD VSS OAI21_X1
X_640_ memory_inst.mem\[5\]\[0\] net3 _116_ _036_ VDD VSS
+ MUX2_X1
X_641_ net9 memory_inst.mem\[4\]\[6\] _115_ _035_ VDD VSS
+ MUX2_X1
X_642_ net8 memory_inst.mem\[4\]\[5\] _115_ _034_ VDD VSS
+ MUX2_X1
X_643_ net7 memory_inst.mem\[4\]\[4\] _115_ _033_ VDD VSS
+ MUX2_X1
X_644_ net6 memory_inst.mem\[4\]\[3\] _115_ _032_ VDD VSS
+ MUX2_X1
X_645_ memory_inst.mem\[1\]\[7\] _107_ VDD VSS INV_X1
X_646_ net5 memory_inst.mem\[4\]\[2\] _115_ _031_ VDD VSS
+ MUX2_X1
X_647_ _115_ net4 _309_ VDD VSS NOR2_X1
X_648_ _309_ _214_ _115_ _030_ VDD VSS AOI21_X1
X_649_ net3 memory_inst.mem\[4\]\[0\] _115_ _029_ VDD VSS
+ MUX2_X1
X_650_ net9 memory_inst.mem\[3\]\[6\] _113_ _028_ VDD VSS
+ MUX2_X1
X_651_ net8 memory_inst.mem\[3\]\[5\] _113_ _027_ VDD VSS
+ MUX2_X1
X_652_ net7 memory_inst.mem\[3\]\[4\] _113_ _026_ VDD VSS
+ MUX2_X1
X_653_ net6 memory_inst.mem\[3\]\[3\] _113_ _025_ VDD VSS
+ MUX2_X1
X_654_ net5 memory_inst.mem\[3\]\[2\] _113_ _024_ VDD VSS
+ MUX2_X1
X_655_ net4 memory_inst.mem\[3\]\[1\] _113_ _023_ VDD VSS
+ MUX2_X1
Xoutput17 net17 read_data[3] VDD VSS BUF_X1
X_657_ _106_ _107_ _104_ _085_ VDD VSS OAI21_X1
X_658_ net3 memory_inst.mem\[3\]\[0\] _113_ _022_ VDD VSS
+ MUX2_X1
X_659_ net9 memory_inst.mem\[2\]\[6\] _108_ _021_ VDD VSS
+ MUX2_X1
X_660_ net8 memory_inst.mem\[2\]\[5\] _108_ _020_ VDD VSS
+ MUX2_X1
X_661_ net5 memory_inst.mem\[2\]\[2\] _108_ _019_ VDD VSS
+ MUX2_X1
X_662_ net7 memory_inst.mem\[2\]\[4\] _108_ _018_ VDD VSS
+ MUX2_X1
X_663_ net6 memory_inst.mem\[2\]\[3\] _108_ _017_ VDD VSS
+ MUX2_X1
X_664_ _092_ _005_ net11 _310_ VDD VSS NAND3_X1
X_665_ _310_ memory_inst.write_addr\[2\] _311_ VDD VSS NAND2_X1
X_666_ _311_ _113_ wr_gray_next.binary\[2\] VDD VSS NAND2_X1
X_667_ rd_to_wr_sync.gray_out\[2\] _312_ VDD VSS INV_X1
X_668_ _003_ _008_ _108_ VDD VSS NAND2_X1
X_669_ wr_gray_next.binary\[2\] _312_ _313_ VDD VSS NAND2_X1
X_670_ _311_ rd_to_wr_sync.gray_out\[2\] _113_ _314_ VDD VSS
+ NAND3_X1
X_671_ _313_ _314_ _315_ VDD VSS NAND2_X1
X_672_ _315_ status_inst.wr_ptr_gray_next\[3\] _316_ VDD VSS
+ NAND2_X1
X_673_ _313_ _314_ rd_to_wr_sync.gray_out\[3\] _317_ VDD VSS
+ NAND3_X1
X_674_ _311_ _089_ _113_ _318_ VDD VSS NAND3_X4
X_675_ wr_gray_next.binary\[1\] memory_inst.write_addr\[2\]
+ _319_ VDD VSS NAND2_X1
X_676_ _318_ _319_ _320_ VDD VSS NAND2_X2
X_677_ _320_ rd_to_wr_sync.gray_out\[1\] _321_ VDD VSS NAND2_X1
X_678_ _316_ _317_ _321_ _322_ VDD VSS NAND3_X2
X_679_ _108_ net10 _109_ VDD VSS NOR2_X1
X_680_ _002_ rd_to_wr_sync.gray_out\[0\] _323_ VDD VSS XNOR2_X1
X_681_ _323_ memory_inst.write_addr\[1\] _324_ VDD VSS XNOR2_X1
X_682_ _324_ status_inst.wr_ptr_gray_next\[3\] rd_to_wr_sync.gray_out\[3\]
+ _325_ VDD VSS OAI21_X1
X_683_ _325_ _326_ VDD VSS INV_X1
X_684_ _320_ rd_to_wr_sync.gray_out\[1\] _327_ VDD VSS OR2_X1
X_685_ _326_ _327_ _328_ VDD VSS NAND2_X2
X_686_ _322_ _328_ full_next VDD VSS NOR2_X2
X_687_ memory_inst.mem\[2\]\[7\] _110_ VDD VSS INV_X1
X_688_ _109_ _110_ _108_ _084_ VDD VSS AOI21_X1
X_689_ _005_ _111_ VDD VSS INV_X1
X_690_ _111_ memory_inst.write_addr\[2\] _112_ VDD VSS NOR2_X2
X_691_ mem_write_en _112_ _113_ VDD VSS NAND2_X2
Xoutput16 net16 read_data[2] VDD VSS BUF_X1
X_693_ net10 memory_inst.mem\[3\]\[7\] _113_ _083_ VDD VSS
+ MUX2_X1
X_694_ _090_ memory_inst.write_addr\[2\] wr_gray_current.gray\[2\]
+ VDD VSS XNOR2_X1
X_695_ _003_ _007_ _115_ VDD VSS NAND2_X1
X_696_ net10 memory_inst.mem\[4\]\[7\] _115_ _082_ VDD VSS
+ MUX2_X1
X_697_ mem_write_en _007_ memory_inst.write_addr\[0\] _116_
+ VDD VSS AND3_X2
Xoutput15 net15 read_data[1] VDD VSS BUF_X1
X_699_ _116_ net10 _118_ VDD VSS NAND2_X1
X_700_ memory_inst.mem\[5\]\[7\] _119_ VDD VSS INV_X1
X_701_ _118_ _119_ _116_ _081_ VDD VSS OAI21_X1
X_702_ _003_ _009_ _120_ VDD VSS NAND2_X1
Xoutput14 net14 read_data[0] VDD VSS BUF_X1
X_704_ _120_ net10 _122_ VDD VSS NOR2_X1
X_705_ net13 _092_ VDD VSS INV_X2
X_706_ memory_inst.mem\[6\]\[7\] _123_ VDD VSS INV_X1
X_707_ _122_ _123_ _120_ _080_ VDD VSS AOI21_X1
X_708_ memory_inst.mem\[7\]\[7\] net10 _094_ _079_ VDD VSS
+ MUX2_X1
Xoutput13 net13 full VDD VSS BUF_X1
X_710_ memory_inst.read_addr\[1\] _125_ VDD VSS INV_X1
Xoutput12 net12 empty VDD VSS BUF_X1
Xinput11 write_en net11 VDD VSS BUF_X1
X_713_ memory_inst.read_addr\[0\] _128_ VDD VSS INV_X2
X_714_ _125_ _128_ _110_ _129_ VDD VSS AOI21_X1
Xinput10 write_data[7] net10 VDD VSS BUF_X1
X_716_ _092_ net11 _001_ VDD VSS NAND2_X4
X_717_ _129_ _128_ memory_inst.mem\[3\]\[7\] _131_ VDD VSS
+ OAI21_X1
Xinput9 write_data[6] net9 VDD VSS BUF_X1
X_719_ memory_inst.read_addr\[2\] _133_ VDD VSS INV_X4
Xinput8 write_data[5] net8 VDD VSS BUF_X1
Xinput7 write_data[4] net7 VDD VSS BUF_X1
X_722_ memory_inst.read_addr\[1\] _107_ net24 _136_ VDD VSS
+ AOI21_X1
Xinput6 write_data[3] net6 VDD VSS BUF_X1
X_724_ _136_ net24 memory_inst.mem\[0\]\[7\] _138_ VDD VSS
+ OAI21_X1
X_725_ _131_ _133_ _138_ _139_ VDD VSS NAND3_X1
X_726_ _125_ _128_ _123_ _140_ VDD VSS AOI21_X1
X_727_ memory_inst.write_addr\[2\] _005_ _093_ VDD VSS NAND2_X4
X_728_ _140_ _128_ memory_inst.mem\[7\]\[7\] _141_ VDD VSS
+ OAI21_X1
X_729_ memory_inst.read_addr\[1\] _119_ net24 _142_ VDD VSS
+ AOI21_X1
X_730_ _142_ net24 memory_inst.mem\[4\]\[7\] _143_ VDD VSS
+ OAI21_X1
X_731_ _141_ memory_inst.read_addr\[2\] _143_ _144_ VDD VSS
+ NAND3_X1
X_732_ _139_ _144_ _095_ _145_ VDD VSS NAND3_X1
X_733_ _014_ net21 _146_ VDD VSS NAND2_X1
X_734_ _145_ _146_ _078_ VDD VSS NAND2_X1
Xinput5 write_data[2] net5 VDD VSS BUF_X1
X_736_ memory_inst.mem\[7\]\[0\] net3 _094_ _077_ VDD VSS
+ MUX2_X1
X_737_ net4 memory_inst.mem\[2\]\[1\] _108_ _076_ VDD VSS
+ MUX2_X1
X_738_ _001_ _093_ _094_ VDD VSS NOR2_X4
X_739_ net3 memory_inst.mem\[2\]\[0\] _108_ _075_ VDD VSS
+ MUX2_X1
X_740_ _133_ rd_gray_current.binary\[3\] rd_gray_current.gray\[2\]
+ VDD VSS XNOR2_X1
Xinput4 write_data[1] net4 VDD VSS BUF_X1
X_742_ _095_ _013_ memory_inst.read_addr\[2\] _149_ VDD VSS
+ NAND3_X1
X_743_ _013_ _150_ VDD VSS INV_X1
X_744_ _133_ _014_ _150_ _151_ VDD VSS OAI21_X2
X_745_ _149_ _151_ _152_ VDD VSS NAND2_X1
X_746_ _152_ rd_gray_next.binary\[2\] VDD VSS INV_X1
X_747_ _116_ net9 _153_ VDD VSS NAND2_X1
X_748_ memory_inst.mem\[5\]\[6\] _154_ VDD VSS INV_X1
X_749_ _094_ _090_ status_inst.wr_ptr_gray_next\[3\] VDD VSS
+ XNOR2_X2
X_750_ _153_ _154_ _116_ _074_ VDD VSS OAI21_X1
Xinput3 write_data[0] net3 VDD VSS BUF_X1
X_752_ memory_inst.mem\[7\]\[3\] net6 _094_ _073_ VDD VSS
+ MUX2_X1
Xinput2 rst_n net2 VDD VSS BUF_X1
X_754_ _116_ net8 _157_ VDD VSS NAND2_X1
X_755_ memory_inst.mem\[5\]\[5\] _158_ VDD VSS INV_X1
X_756_ _157_ _158_ _116_ _072_ VDD VSS OAI21_X1
X_757_ memory_inst.mem\[7\]\[5\] net8 _094_ _071_ VDD VSS
+ MUX2_X1
Xinput1 read_en net1 VDD VSS BUF_X1
X_759_ memory_inst.mem\[7\]\[2\] net5 _094_ _070_ VDD VSS
+ MUX2_X1
X_760_ _001_ _422_ _002_ wr_gray_next.binary\[0\] VDD VSS
+ HA_X1
X_761_ mem_write_en _422_ _003_ _423_ VDD VSS HA_X1
X_762_ mem_write_en memory_inst.write_addr\[0\] _004_ _424_
+ VDD VSS HA_X1
X_763_ memory_inst.write_addr\[0\] memory_inst.write_addr\[1\]
+ _005_ wr_gray_current.gray\[0\] VDD VSS HA_X1
X_764_ _425_ _426_ _006_ wr_gray_current.gray\[1\] VDD VSS
+ HA_X1
X_765_ _425_ memory_inst.write_addr\[2\] _007_ _427_ VDD VSS
+ HA_X1
X_766_ memory_inst.write_addr\[1\] _426_ _008_ _428_ VDD VSS
+ HA_X1
X_767_ memory_inst.write_addr\[1\] memory_inst.write_addr\[2\]
+ _009_ _429_ VDD VSS HA_X1
X_768_ memory_inst.read_addr\[1\] memory_inst.read_addr\[2\]
+ _010_ rd_gray_current.gray\[1\] VDD VSS HA_X1
X_769_ _430_ memory_inst.read_addr\[1\] _011_ _012_ VDD VSS
+ HA_X1
X_770_ memory_inst.read_addr\[0\] memory_inst.read_addr\[1\]
+ _013_ _431_ VDD VSS HA_X1
X_771_ _014_ _430_ _015_ rd_gray_next.binary\[0\] VDD VSS
+ HA_X1
X_772_ _095_ memory_inst.read_addr\[0\] _016_ _432_ VDD VSS
+ HA_X1
Xempty$_DFF_PN1_ empty_next net2 clknet_1_1__leaf_read_clk
+ net12 _000_ VDD VSS DFFS_X1
Xfull$_DFF_PN0_ full_next net25 clknet_3_2__leaf_write_clk
+ net13 _331_ VDD VSS DFFR_X1
Xmemory_inst.mem\[0\]\[0\]$_DFFE_PP_ _041_ clknet_3_7__leaf_write_clk
+ memory_inst.mem\[0\]\[0\] _376_ VDD VSS DFF_X1
Xmemory_inst.mem\[0\]\[1\]$_DFFE_PP_ _042_ clknet_3_7__leaf_write_clk
+ memory_inst.mem\[0\]\[1\] _375_ VDD VSS DFF_X1
Xmemory_inst.mem\[0\]\[2\]$_DFFE_PP_ _043_ clknet_3_0__leaf_write_clk
+ memory_inst.mem\[0\]\[2\] _374_ VDD VSS DFF_X1
Xmemory_inst.mem\[0\]\[3\]$_DFFE_PP_ _044_ clknet_3_0__leaf_write_clk
+ memory_inst.mem\[0\]\[3\] _373_ VDD VSS DFF_X1
Xmemory_inst.mem\[0\]\[4\]$_DFFE_PP_ _045_ clknet_3_0__leaf_write_clk
+ memory_inst.mem\[0\]\[4\] _372_ VDD VSS DFF_X1
Xmemory_inst.mem\[0\]\[5\]$_DFFE_PP_ _046_ clknet_3_5__leaf_write_clk
+ memory_inst.mem\[0\]\[5\] _371_ VDD VSS DFF_X1
Xmemory_inst.mem\[0\]\[6\]$_DFFE_PP_ _047_ clknet_3_5__leaf_write_clk
+ memory_inst.mem\[0\]\[6\] _370_ VDD VSS DFF_X1
Xmemory_inst.mem\[0\]\[7\]$_DFFE_PP_ _086_ clknet_3_4__leaf_write_clk
+ memory_inst.mem\[0\]\[7\] _414_ VDD VSS DFF_X1
Xmemory_inst.mem\[1\]\[0\]$_DFFE_PP_ _048_ clknet_3_7__leaf_write_clk
+ memory_inst.mem\[1\]\[0\] _369_ VDD VSS DFF_X1
Xmemory_inst.mem\[1\]\[1\]$_DFFE_PP_ _049_ clknet_3_7__leaf_write_clk
+ memory_inst.mem\[1\]\[1\] _368_ VDD VSS DFF_X1
Xmemory_inst.mem\[1\]\[2\]$_DFFE_PP_ _050_ clknet_3_1__leaf_write_clk
+ memory_inst.mem\[1\]\[2\] _367_ VDD VSS DFF_X1
Xmemory_inst.mem\[1\]\[3\]$_DFFE_PP_ _051_ clknet_3_0__leaf_write_clk
+ memory_inst.mem\[1\]\[3\] _366_ VDD VSS DFF_X1
Xmemory_inst.mem\[1\]\[4\]$_DFFE_PP_ _052_ clknet_3_0__leaf_write_clk
+ memory_inst.mem\[1\]\[4\] _365_ VDD VSS DFF_X1
Xmemory_inst.mem\[1\]\[5\]$_DFFE_PP_ _067_ clknet_3_5__leaf_write_clk
+ memory_inst.mem\[1\]\[5\] _411_ VDD VSS DFF_X1
Xmemory_inst.mem\[1\]\[6\]$_DFFE_PP_ _068_ clknet_3_5__leaf_write_clk
+ memory_inst.mem\[1\]\[6\] _349_ VDD VSS DFF_X1
Xmemory_inst.mem\[1\]\[7\]$_DFFE_PP_ _085_ clknet_3_5__leaf_write_clk
+ memory_inst.mem\[1\]\[7\] _332_ VDD VSS DFF_X1
Xmemory_inst.mem\[2\]\[0\]$_DFFE_PP_ _075_ clknet_3_7__leaf_write_clk
+ memory_inst.mem\[2\]\[0\] _342_ VDD VSS DFF_X1
Xmemory_inst.mem\[2\]\[1\]$_DFFE_PP_ _076_ clknet_3_7__leaf_write_clk
+ memory_inst.mem\[2\]\[1\] _341_ VDD VSS DFF_X1
Xmemory_inst.mem\[2\]\[2\]$_DFFE_PP_ _019_ clknet_3_0__leaf_write_clk
+ memory_inst.mem\[2\]\[2\] _397_ VDD VSS DFF_X1
Xmemory_inst.mem\[2\]\[3\]$_DFFE_PP_ _017_ clknet_3_0__leaf_write_clk
+ memory_inst.mem\[2\]\[3\] _399_ VDD VSS DFF_X1
Xmemory_inst.mem\[2\]\[4\]$_DFFE_PP_ _018_ clknet_3_0__leaf_write_clk
+ memory_inst.mem\[2\]\[4\] _400_ VDD VSS DFF_X1
Xmemory_inst.mem\[2\]\[5\]$_DFFE_PP_ _020_ clknet_3_5__leaf_write_clk
+ memory_inst.mem\[2\]\[5\] _396_ VDD VSS DFF_X1
Xmemory_inst.mem\[2\]\[6\]$_DFFE_PP_ _021_ clknet_3_5__leaf_write_clk
+ memory_inst.mem\[2\]\[6\] _395_ VDD VSS DFF_X1
Xmemory_inst.mem\[2\]\[7\]$_DFFE_PP_ _084_ clknet_3_7__leaf_write_clk
+ memory_inst.mem\[2\]\[7\] _333_ VDD VSS DFF_X1
Xmemory_inst.mem\[3\]\[0\]$_DFFE_PP_ _022_ clknet_3_6__leaf_write_clk
+ memory_inst.mem\[3\]\[0\] _394_ VDD VSS DFF_X1
Xmemory_inst.mem\[3\]\[1\]$_DFFE_PP_ _023_ clknet_3_6__leaf_write_clk
+ memory_inst.mem\[3\]\[1\] _393_ VDD VSS DFF_X1
Xmemory_inst.mem\[3\]\[2\]$_DFFE_PP_ _024_ clknet_3_3__leaf_write_clk
+ memory_inst.mem\[3\]\[2\] _392_ VDD VSS DFF_X1
Xmemory_inst.mem\[3\]\[3\]$_DFFE_PP_ _025_ clknet_3_3__leaf_write_clk
+ memory_inst.mem\[3\]\[3\] _391_ VDD VSS DFF_X1
Xmemory_inst.mem\[3\]\[4\]$_DFFE_PP_ _026_ clknet_3_2__leaf_write_clk
+ memory_inst.mem\[3\]\[4\] _390_ VDD VSS DFF_X1
Xmemory_inst.mem\[3\]\[5\]$_DFFE_PP_ _027_ clknet_3_4__leaf_write_clk
+ memory_inst.mem\[3\]\[5\] _389_ VDD VSS DFF_X1
Xmemory_inst.mem\[3\]\[6\]$_DFFE_PP_ _028_ clknet_3_4__leaf_write_clk
+ memory_inst.mem\[3\]\[6\] _388_ VDD VSS DFF_X1
Xmemory_inst.mem\[3\]\[7\]$_DFFE_PP_ _083_ clknet_3_6__leaf_write_clk
+ memory_inst.mem\[3\]\[7\] _334_ VDD VSS DFF_X1
Xmemory_inst.mem\[4\]\[0\]$_DFFE_PP_ _029_ clknet_3_7__leaf_write_clk
+ memory_inst.mem\[4\]\[0\] _387_ VDD VSS DFF_X1
Xmemory_inst.mem\[4\]\[1\]$_DFFE_PP_ _030_ clknet_3_7__leaf_write_clk
+ memory_inst.mem\[4\]\[1\] _386_ VDD VSS DFF_X1
Xmemory_inst.mem\[4\]\[2\]$_DFFE_PP_ _031_ clknet_3_1__leaf_write_clk
+ memory_inst.mem\[4\]\[2\] _385_ VDD VSS DFF_X1
Xmemory_inst.mem\[4\]\[3\]$_DFFE_PP_ _032_ clknet_3_1__leaf_write_clk
+ memory_inst.mem\[4\]\[3\] _384_ VDD VSS DFF_X1
Xmemory_inst.mem\[4\]\[4\]$_DFFE_PP_ _033_ clknet_3_1__leaf_write_clk
+ memory_inst.mem\[4\]\[4\] _403_ VDD VSS DFF_X1
Xmemory_inst.mem\[4\]\[5\]$_DFFE_PP_ _034_ clknet_3_5__leaf_write_clk
+ memory_inst.mem\[4\]\[5\] _383_ VDD VSS DFF_X1
Xmemory_inst.mem\[4\]\[6\]$_DFFE_PP_ _035_ clknet_3_5__leaf_write_clk
+ memory_inst.mem\[4\]\[6\] _382_ VDD VSS DFF_X1
Xmemory_inst.mem\[4\]\[7\]$_DFFE_PP_ _082_ clknet_3_4__leaf_write_clk
+ memory_inst.mem\[4\]\[7\] _335_ VDD VSS DFF_X1
Xmemory_inst.mem\[5\]\[0\]$_DFFE_PP_ _036_ clknet_3_7__leaf_write_clk
+ memory_inst.mem\[5\]\[0\] _381_ VDD VSS DFF_X1
Xmemory_inst.mem\[5\]\[1\]$_DFFE_PP_ _037_ clknet_3_6__leaf_write_clk
+ memory_inst.mem\[5\]\[1\] _380_ VDD VSS DFF_X1
Xmemory_inst.mem\[5\]\[2\]$_DFFE_PP_ _038_ clknet_3_1__leaf_write_clk
+ memory_inst.mem\[5\]\[2\] _379_ VDD VSS DFF_X1
Xmemory_inst.mem\[5\]\[3\]$_DFFE_PP_ _039_ clknet_3_1__leaf_write_clk
+ memory_inst.mem\[5\]\[3\] _378_ VDD VSS DFF_X1
Xmemory_inst.mem\[5\]\[4\]$_DFFE_PP_ _040_ clknet_3_1__leaf_write_clk
+ memory_inst.mem\[5\]\[4\] _404_ VDD VSS DFF_X1
Xmemory_inst.mem\[5\]\[5\]$_DFFE_PP_ _072_ clknet_3_4__leaf_write_clk
+ memory_inst.mem\[5\]\[5\] _345_ VDD VSS DFF_X1
Xmemory_inst.mem\[5\]\[6\]$_DFFE_PP_ _074_ clknet_3_4__leaf_write_clk
+ memory_inst.mem\[5\]\[6\] _413_ VDD VSS DFF_X1
Xmemory_inst.mem\[5\]\[7\]$_DFFE_PP_ _081_ clknet_3_4__leaf_write_clk
+ memory_inst.mem\[5\]\[7\] _336_ VDD VSS DFF_X1
Xmemory_inst.mem\[6\]\[0\]$_DFFE_PP_ _053_ clknet_3_6__leaf_write_clk
+ memory_inst.mem\[6\]\[0\] _364_ VDD VSS DFF_X1
Xmemory_inst.mem\[6\]\[1\]$_DFFE_PP_ _054_ clknet_3_6__leaf_write_clk
+ memory_inst.mem\[6\]\[1\] _363_ VDD VSS DFF_X1
Xmemory_inst.mem\[6\]\[2\]$_DFFE_PP_ _055_ clknet_3_1__leaf_write_clk
+ memory_inst.mem\[6\]\[2\] _362_ VDD VSS DFF_X1
Xmemory_inst.mem\[6\]\[3\]$_DFFE_PP_ _056_ clknet_3_3__leaf_write_clk
+ memory_inst.mem\[6\]\[3\] _361_ VDD VSS DFF_X1
Xmemory_inst.mem\[6\]\[4\]$_DFFE_PP_ _057_ clknet_3_1__leaf_write_clk
+ memory_inst.mem\[6\]\[4\] _360_ VDD VSS DFF_X1
Xmemory_inst.mem\[6\]\[5\]$_DFFE_PP_ _058_ clknet_3_4__leaf_write_clk
+ memory_inst.mem\[6\]\[5\] _359_ VDD VSS DFF_X1
Xmemory_inst.mem\[6\]\[6\]$_DFFE_PP_ _059_ clknet_3_4__leaf_write_clk
+ memory_inst.mem\[6\]\[6\] _358_ VDD VSS DFF_X1
Xmemory_inst.mem\[6\]\[7\]$_DFFE_PP_ _080_ clknet_3_4__leaf_write_clk
+ memory_inst.mem\[6\]\[7\] _337_ VDD VSS DFF_X1
Xmemory_inst.mem\[7\]\[0\]$_DFFE_PP_ _077_ clknet_3_6__leaf_write_clk
+ memory_inst.mem\[7\]\[0\] _340_ VDD VSS DFF_X1
Xmemory_inst.mem\[7\]\[1\]$_DFFE_PP_ _088_ clknet_3_6__leaf_write_clk
+ memory_inst.mem\[7\]\[1\] _418_ VDD VSS DFF_X1
Xmemory_inst.mem\[7\]\[2\]$_DFFE_PP_ _070_ clknet_3_0__leaf_write_clk
+ memory_inst.mem\[7\]\[2\] _347_ VDD VSS DFF_X1
Xmemory_inst.mem\[7\]\[3\]$_DFFE_PP_ _073_ clknet_3_3__leaf_write_clk
+ memory_inst.mem\[7\]\[3\] _344_ VDD VSS DFF_X1
Xmemory_inst.mem\[7\]\[4\]$_DFFE_PP_ _069_ clknet_3_3__leaf_write_clk
+ memory_inst.mem\[7\]\[4\] _348_ VDD VSS DFF_X1
Xmemory_inst.mem\[7\]\[5\]$_DFFE_PP_ _071_ clknet_3_4__leaf_write_clk
+ memory_inst.mem\[7\]\[5\] _346_ VDD VSS DFF_X1
Xmemory_inst.mem\[7\]\[6\]$_DFFE_PP_ _087_ clknet_3_4__leaf_write_clk
+ memory_inst.mem\[7\]\[6\] _415_ VDD VSS DFF_X1
Xmemory_inst.mem\[7\]\[7\]$_DFFE_PP_ _079_ clknet_3_6__leaf_write_clk
+ memory_inst.mem\[7\]\[7\] _338_ VDD VSS DFF_X1
Xmemory_inst.read_data\[0\]$_DFFE_PP_ _066_ clknet_1_1__leaf_read_clk
+ net14 _351_ VDD VSS DFF_X1
Xmemory_inst.read_data\[1\]$_DFFE_PP_ _065_ clknet_1_1__leaf_read_clk
+ net15 _352_ VDD VSS DFF_X1
Xmemory_inst.read_data\[2\]$_DFFE_PP_ _064_ clknet_1_0__leaf_read_clk
+ net16 _353_ VDD VSS DFF_X1
Xmemory_inst.read_data\[3\]$_DFFE_PP_ _063_ clknet_1_0__leaf_read_clk
+ net17 _354_ VDD VSS DFF_X1
Xmemory_inst.read_data\[4\]$_DFFE_PP_ _062_ clknet_1_0__leaf_read_clk
+ net18 _355_ VDD VSS DFF_X1
Xmemory_inst.read_data\[5\]$_DFFE_PP_ _061_ clknet_1_1__leaf_read_clk
+ net19 _356_ VDD VSS DFF_X1
Xmemory_inst.read_data\[6\]$_DFFE_PP_ _060_ clknet_1_1__leaf_read_clk
+ net20 _357_ VDD VSS DFF_X1
Xmemory_inst.read_data\[7\]$_DFFE_PP_ _078_ clknet_1_1__leaf_read_clk
+ net21 _339_ VDD VSS DFF_X1
Xrd_to_wr_sync.gray_out\[0\]$_DFF_PN0_ rd_to_wr_sync.sync_ff1\[0\]
+ net2 clknet_3_6__leaf_write_clk rd_to_wr_sync.gray_out\[0\]
+ _398_ VDD VSS DFFR_X1
Xrd_to_wr_sync.gray_out\[1\]$_DFF_PN0_ rd_to_wr_sync.sync_ff1\[1\]
+ net25 clknet_3_2__leaf_write_clk rd_to_wr_sync.gray_out\[1\]
+ _410_ VDD VSS DFFR_X1
Xrd_to_wr_sync.gray_out\[2\]$_DFF_PN0_ rd_to_wr_sync.sync_ff1\[2\]
+ net25 clknet_3_2__leaf_write_clk rd_to_wr_sync.gray_out\[2\]
+ _377_ VDD VSS DFFR_X1
Xrd_to_wr_sync.gray_out\[3\]$_DFF_PN0_ rd_to_wr_sync.sync_ff1\[3\]
+ net25 clknet_3_2__leaf_write_clk rd_to_wr_sync.gray_out\[3\]
+ _417_ VDD VSS DFFR_X1
Xrd_to_wr_sync.sync_ff1\[0\]$_DFF_PN0_ rd_gray_current.gray\[0\]
+ net2 clknet_3_3__leaf_write_clk rd_to_wr_sync.sync_ff1\[0\]
+ _408_ VDD VSS DFFR_X1
Xrd_to_wr_sync.sync_ff1\[1\]$_DFF_PN0_ rd_gray_current.gray\[1\]
+ net25 clknet_3_2__leaf_write_clk rd_to_wr_sync.sync_ff1\[1\]
+ _409_ VDD VSS DFFR_X1
Xrd_to_wr_sync.sync_ff1\[2\]$_DFF_PN0_ rd_gray_current.gray\[2\]
+ net25 clknet_3_2__leaf_write_clk rd_to_wr_sync.sync_ff1\[2\]
+ _343_ VDD VSS DFFR_X1
Xrd_to_wr_sync.sync_ff1\[3\]$_DFF_PN0_ rd_gray_current.binary\[3\]
+ net25 clknet_3_2__leaf_write_clk rd_to_wr_sync.sync_ff1\[3\]
+ _330_ VDD VSS DFFR_X1
Xread_pointer_inst.rd_ptr_bin\[0\]$_DFF_PN0_ rd_gray_next.binary\[0\]
+ net25 clknet_1_0__leaf_read_clk memory_inst.read_addr\[0\]
+ _430_ VDD VSS DFFR_X1
Xread_pointer_inst.rd_ptr_bin\[1\]$_DFF_PN0_ rd_gray_next.binary\[1\]
+ net2 clknet_1_1__leaf_read_clk memory_inst.read_addr\[1\]
+ _402_ VDD VSS DFFR_X1
Xread_pointer_inst.rd_ptr_bin\[2\]$_DFF_PN0_ rd_gray_next.binary\[2\]
+ net2 clknet_1_1__leaf_read_clk memory_inst.read_addr\[2\]
+ _401_ VDD VSS DFFR_X1
Xread_pointer_inst.rd_ptr_bin\[3\]$_DFF_PN0_ rd_gray_next.binary\[3\]
+ net25 clknet_1_0__leaf_read_clk rd_gray_current.binary\[3\]
+ _419_ VDD VSS DFFR_X1
Xwr_to_rd_sync.gray_out\[0\]$_DFF_PN0_ wr_to_rd_sync.sync_ff1\[0\]
+ net25 clknet_1_0__leaf_read_clk status_inst.synced_wr_ptr_gray\[0\]
+ _412_ VDD VSS DFFR_X1
Xwr_to_rd_sync.gray_out\[1\]$_DFF_PN0_ wr_to_rd_sync.sync_ff1\[1\]
+ net2 clknet_1_1__leaf_read_clk status_inst.synced_wr_ptr_gray\[1\]
+ _416_ VDD VSS DFFR_X1
Xwr_to_rd_sync.gray_out\[2\]$_DFF_PN0_ wr_to_rd_sync.sync_ff1\[2\]
+ net25 clknet_1_0__leaf_read_clk status_inst.synced_wr_ptr_gray\[2\]
+ _407_ VDD VSS DFFR_X1
Xwr_to_rd_sync.gray_out\[3\]$_DFF_PN0_ wr_to_rd_sync.sync_ff1\[3\]
+ net25 clknet_1_0__leaf_read_clk status_inst.synced_wr_ptr_gray\[3\]
+ _420_ VDD VSS DFFR_X1
Xwr_to_rd_sync.sync_ff1\[0\]$_DFF_PN0_ wr_gray_current.gray\[0\]
+ net25 clknet_1_0__leaf_read_clk wr_to_rd_sync.sync_ff1\[0\]
+ _405_ VDD VSS DFFR_X1
Xwr_to_rd_sync.sync_ff1\[1\]$_DFF_PN0_ wr_gray_current.gray\[1\]
+ net2 clknet_1_0__leaf_read_clk wr_to_rd_sync.sync_ff1\[1\]
+ _406_ VDD VSS DFFR_X1
Xwr_to_rd_sync.sync_ff1\[2\]$_DFF_PN0_ wr_gray_current.gray\[2\]
+ net25 clknet_1_0__leaf_read_clk wr_to_rd_sync.sync_ff1\[2\]
+ _350_ VDD VSS DFFR_X1
Xwr_to_rd_sync.sync_ff1\[3\]$_DFF_PN0_ wr_gray_current.binary\[3\]
+ net25 clknet_1_0__leaf_read_clk wr_to_rd_sync.sync_ff1\[3\]
+ _421_ VDD VSS DFFR_X1
Xwrite_pointer_inst.wr_ptr_bin\[0\]$_DFF_PN0_ wr_gray_next.binary\[0\]
+ net25 clknet_3_3__leaf_write_clk memory_inst.write_addr\[0\]
+ _422_ VDD VSS DFFR_X1
Xwrite_pointer_inst.wr_ptr_bin\[1\]$_DFF_PN0_ wr_gray_next.binary\[1\]
+ net25 clknet_3_3__leaf_write_clk memory_inst.write_addr\[1\]
+ _425_ VDD VSS DFFR_X1
Xwrite_pointer_inst.wr_ptr_bin\[2\]$_DFF_PN0_ wr_gray_next.binary\[2\]
+ net25 clknet_3_2__leaf_write_clk memory_inst.write_addr\[2\]
+ _426_ VDD VSS DFFR_X1
Xwrite_pointer_inst.wr_ptr_bin\[3\]$_DFF_PN0_ status_inst.wr_ptr_gray_next\[3\]
+ net25 clknet_3_2__leaf_write_clk wr_gray_current.binary\[3\]
+ _329_ VDD VSS DFFR_X1
XPHY_EDGE_ROW_0_Right_0 VDD VSS TAPCELL_X1
XPHY_EDGE_ROW_1_Right_1 VDD VSS TAPCELL_X1
XPHY_EDGE_ROW_2_Right_2 VDD VSS TAPCELL_X1
XPHY_EDGE_ROW_3_Right_3 VDD VSS TAPCELL_X1
XPHY_EDGE_ROW_4_Right_4 VDD VSS TAPCELL_X1
XPHY_EDGE_ROW_5_Right_5 VDD VSS TAPCELL_X1
XPHY_EDGE_ROW_6_Right_6 VDD VSS TAPCELL_X1
XPHY_EDGE_ROW_7_Right_7 VDD VSS TAPCELL_X1
XPHY_EDGE_ROW_8_Right_8 VDD VSS TAPCELL_X1
XPHY_EDGE_ROW_9_Right_9 VDD VSS TAPCELL_X1
XPHY_EDGE_ROW_10_Right_10 VDD VSS TAPCELL_X1
XPHY_EDGE_ROW_11_Right_11 VDD VSS TAPCELL_X1
XPHY_EDGE_ROW_12_Right_12 VDD VSS TAPCELL_X1
XPHY_EDGE_ROW_13_Right_13 VDD VSS TAPCELL_X1
XPHY_EDGE_ROW_14_Right_14 VDD VSS TAPCELL_X1
XPHY_EDGE_ROW_15_Right_15 VDD VSS TAPCELL_X1
XPHY_EDGE_ROW_16_Right_16 VDD VSS TAPCELL_X1
XPHY_EDGE_ROW_17_Right_17 VDD VSS TAPCELL_X1
XPHY_EDGE_ROW_18_Right_18 VDD VSS TAPCELL_X1
XPHY_EDGE_ROW_19_Right_19 VDD VSS TAPCELL_X1
XPHY_EDGE_ROW_20_Right_20 VDD VSS TAPCELL_X1
XPHY_EDGE_ROW_21_Right_21 VDD VSS TAPCELL_X1
XPHY_EDGE_ROW_22_Right_22 VDD VSS TAPCELL_X1
XPHY_EDGE_ROW_23_Right_23 VDD VSS TAPCELL_X1
XPHY_EDGE_ROW_24_Right_24 VDD VSS TAPCELL_X1
XPHY_EDGE_ROW_25_Right_25 VDD VSS TAPCELL_X1
XPHY_EDGE_ROW_26_Right_26 VDD VSS TAPCELL_X1
XPHY_EDGE_ROW_27_Right_27 VDD VSS TAPCELL_X1
XPHY_EDGE_ROW_28_Right_28 VDD VSS TAPCELL_X1
XPHY_EDGE_ROW_0_Left_29 VDD VSS TAPCELL_X1
XPHY_EDGE_ROW_1_Left_30 VDD VSS TAPCELL_X1
XPHY_EDGE_ROW_2_Left_31 VDD VSS TAPCELL_X1
XPHY_EDGE_ROW_3_Left_32 VDD VSS TAPCELL_X1
XPHY_EDGE_ROW_4_Left_33 VDD VSS TAPCELL_X1
XPHY_EDGE_ROW_5_Left_34 VDD VSS TAPCELL_X1
XPHY_EDGE_ROW_6_Left_35 VDD VSS TAPCELL_X1
XPHY_EDGE_ROW_7_Left_36 VDD VSS TAPCELL_X1
XPHY_EDGE_ROW_8_Left_37 VDD VSS TAPCELL_X1
XPHY_EDGE_ROW_9_Left_38 VDD VSS TAPCELL_X1
XPHY_EDGE_ROW_10_Left_39 VDD VSS TAPCELL_X1
XPHY_EDGE_ROW_11_Left_40 VDD VSS TAPCELL_X1
XPHY_EDGE_ROW_12_Left_41 VDD VSS TAPCELL_X1
XPHY_EDGE_ROW_13_Left_42 VDD VSS TAPCELL_X1
XPHY_EDGE_ROW_14_Left_43 VDD VSS TAPCELL_X1
XPHY_EDGE_ROW_15_Left_44 VDD VSS TAPCELL_X1
XPHY_EDGE_ROW_16_Left_45 VDD VSS TAPCELL_X1
XPHY_EDGE_ROW_17_Left_46 VDD VSS TAPCELL_X1
XPHY_EDGE_ROW_18_Left_47 VDD VSS TAPCELL_X1
XPHY_EDGE_ROW_19_Left_48 VDD VSS TAPCELL_X1
XPHY_EDGE_ROW_20_Left_49 VDD VSS TAPCELL_X1
XPHY_EDGE_ROW_21_Left_50 VDD VSS TAPCELL_X1
XPHY_EDGE_ROW_22_Left_51 VDD VSS TAPCELL_X1
XPHY_EDGE_ROW_23_Left_52 VDD VSS TAPCELL_X1
XPHY_EDGE_ROW_24_Left_53 VDD VSS TAPCELL_X1
XPHY_EDGE_ROW_25_Left_54 VDD VSS TAPCELL_X1
XPHY_EDGE_ROW_26_Left_55 VDD VSS TAPCELL_X1
XPHY_EDGE_ROW_27_Left_56 VDD VSS TAPCELL_X1
XPHY_EDGE_ROW_28_Left_57 VDD VSS TAPCELL_X1
Xclkbuf_3_1__f_write_clk clknet_0_write_clk clknet_3_1__leaf_write_clk
+ VDD VSS CLKBUF_X3
Xclkbuf_3_2__f_write_clk clknet_0_write_clk clknet_3_2__leaf_write_clk
+ VDD VSS CLKBUF_X3
Xclkbuf_3_3__f_write_clk clknet_0_write_clk clknet_3_3__leaf_write_clk
+ VDD VSS CLKBUF_X3
Xclkbuf_3_4__f_write_clk clknet_0_write_clk clknet_3_4__leaf_write_clk
+ VDD VSS CLKBUF_X3
Xclkbuf_3_5__f_write_clk clknet_0_write_clk clknet_3_5__leaf_write_clk
+ VDD VSS CLKBUF_X3
Xclkbuf_3_6__f_write_clk clknet_0_write_clk clknet_3_6__leaf_write_clk
+ VDD VSS CLKBUF_X3
Xclkbuf_3_7__f_write_clk clknet_0_write_clk clknet_3_7__leaf_write_clk
+ VDD VSS CLKBUF_X3
Xclkload0 clknet_3_0__leaf_write_clk _unconnected_0 VDD VSS
+ INV_X2
Xclkload1 clknet_3_1__leaf_write_clk _unconnected_1 VDD VSS
+ INV_X2
Xclkload2 clknet_3_2__leaf_write_clk _unconnected_2 VDD VSS
+ INV_X1
Xclkload3 clknet_3_3__leaf_write_clk _unconnected_3 VDD VSS
+ INV_X2
Xclkload4 clknet_3_5__leaf_write_clk _unconnected_4 VDD VSS
+ INV_X2
Xclkload5 clknet_3_6__leaf_write_clk _unconnected_5 VDD VSS
+ INV_X1
Xclkload6 clknet_3_7__leaf_write_clk _unconnected_6 VDD VSS
+ INV_X1
Xclkbuf_0_read_clk read_clk clknet_0_read_clk VDD VSS CLKBUF_X3
Xclkbuf_1_0__f_read_clk clknet_0_read_clk clknet_1_0__leaf_read_clk
+ VDD VSS CLKBUF_X3
Xclkbuf_1_1__f_read_clk clknet_0_read_clk clknet_1_1__leaf_read_clk
+ VDD VSS CLKBUF_X3
Xclkload7 clknet_1_1__leaf_read_clk _unconnected_7 VDD VSS
+ INV_X2
.ENDS async_fifo
